* NGSPICE file created from az_v_uart_top.ext - technology: gf180mcuD

* Black-box entry subcircuit for gf180mcu_fd_sc_mcu7t5v0__filltie abstract view
.subckt gf180mcu_fd_sc_mcu7t5v0__filltie VDD VSS
.ends

* Black-box entry subcircuit for gf180mcu_fd_sc_mcu7t5v0__mux4_1 abstract view
.subckt gf180mcu_fd_sc_mcu7t5v0__mux4_1 I0 I1 I2 I3 S0 S1 Z VDD VNW VPW VSS
.ends

* Black-box entry subcircuit for gf180mcu_fd_sc_mcu7t5v0__mux2_2 abstract view
.subckt gf180mcu_fd_sc_mcu7t5v0__mux2_2 I0 I1 S Z VDD VNW VPW VSS
.ends

* Black-box entry subcircuit for gf180mcu_fd_sc_mcu7t5v0__nor2_1 abstract view
.subckt gf180mcu_fd_sc_mcu7t5v0__nor2_1 A1 A2 ZN VDD VNW VPW VSS
.ends

* Black-box entry subcircuit for gf180mcu_fd_sc_mcu7t5v0__fillcap_4 abstract view
.subckt gf180mcu_fd_sc_mcu7t5v0__fillcap_4 VDD VNW VPW VSS
.ends

* Black-box entry subcircuit for gf180mcu_fd_sc_mcu7t5v0__fill_2 abstract view
.subckt gf180mcu_fd_sc_mcu7t5v0__fill_2 VDD VNW VPW VSS
.ends

* Black-box entry subcircuit for gf180mcu_fd_sc_mcu7t5v0__endcap abstract view
.subckt gf180mcu_fd_sc_mcu7t5v0__endcap VDD VSS
.ends

* Black-box entry subcircuit for gf180mcu_fd_sc_mcu7t5v0__dffrnq_1 abstract view
.subckt gf180mcu_fd_sc_mcu7t5v0__dffrnq_1 D RN CLK Q VDD VNW VPW VSS
.ends

* Black-box entry subcircuit for gf180mcu_fd_sc_mcu7t5v0__fillcap_8 abstract view
.subckt gf180mcu_fd_sc_mcu7t5v0__fillcap_8 VDD VNW VPW VSS
.ends

* Black-box entry subcircuit for gf180mcu_fd_sc_mcu7t5v0__fillcap_16 abstract view
.subckt gf180mcu_fd_sc_mcu7t5v0__fillcap_16 VDD VNW VPW VSS
.ends

* Black-box entry subcircuit for gf180mcu_fd_sc_mcu7t5v0__fillcap_32 abstract view
.subckt gf180mcu_fd_sc_mcu7t5v0__fillcap_32 VDD VNW VPW VSS
.ends

* Black-box entry subcircuit for gf180mcu_fd_sc_mcu7t5v0__fill_1 abstract view
.subckt gf180mcu_fd_sc_mcu7t5v0__fill_1 VDD VNW VPW VSS
.ends

* Black-box entry subcircuit for gf180mcu_fd_sc_mcu7t5v0__fillcap_64 abstract view
.subckt gf180mcu_fd_sc_mcu7t5v0__fillcap_64 VDD VNW VPW VSS
.ends

* Black-box entry subcircuit for gf180mcu_fd_sc_mcu7t5v0__dffq_1 abstract view
.subckt gf180mcu_fd_sc_mcu7t5v0__dffq_1 D CLK Q VDD VNW VPW VSS
.ends

* Black-box entry subcircuit for gf180mcu_fd_sc_mcu7t5v0__dlyc_1 abstract view
.subckt gf180mcu_fd_sc_mcu7t5v0__dlyc_1 I Z VDD VNW VPW VSS
.ends

* Black-box entry subcircuit for gf180mcu_fd_sc_mcu7t5v0__oai211_2 abstract view
.subckt gf180mcu_fd_sc_mcu7t5v0__oai211_2 A1 A2 B C ZN VDD VNW VPW VSS
.ends

* Black-box entry subcircuit for gf180mcu_fd_sc_mcu7t5v0__nor3_1 abstract view
.subckt gf180mcu_fd_sc_mcu7t5v0__nor3_1 A1 A2 A3 ZN VDD VNW VPW VSS
.ends

* Black-box entry subcircuit for gf180mcu_fd_sc_mcu7t5v0__nand2_1 abstract view
.subckt gf180mcu_fd_sc_mcu7t5v0__nand2_1 A1 A2 ZN VDD VNW VPW VSS
.ends

* Black-box entry subcircuit for gf180mcu_fd_sc_mcu7t5v0__nand4_1 abstract view
.subckt gf180mcu_fd_sc_mcu7t5v0__nand4_1 A1 A2 A3 A4 ZN VDD VNW VPW VSS
.ends

* Black-box entry subcircuit for gf180mcu_fd_sc_mcu7t5v0__oai31_2 abstract view
.subckt gf180mcu_fd_sc_mcu7t5v0__oai31_2 A1 A2 A3 B ZN VDD VNW VPW VSS
.ends

* Black-box entry subcircuit for gf180mcu_fd_sc_mcu7t5v0__clkinv_1 abstract view
.subckt gf180mcu_fd_sc_mcu7t5v0__clkinv_1 I ZN VDD VNW VPW VSS
.ends

* Black-box entry subcircuit for gf180mcu_fd_sc_mcu7t5v0__nand3_1 abstract view
.subckt gf180mcu_fd_sc_mcu7t5v0__nand3_1 A1 A2 A3 ZN VDD VNW VPW VSS
.ends

* Black-box entry subcircuit for gf180mcu_fd_sc_mcu7t5v0__oai22_1 abstract view
.subckt gf180mcu_fd_sc_mcu7t5v0__oai22_1 A1 A2 B1 B2 ZN VDD VNW VPW VSS
.ends

* Black-box entry subcircuit for gf180mcu_fd_sc_mcu7t5v0__aoi222_1 abstract view
.subckt gf180mcu_fd_sc_mcu7t5v0__aoi222_1 A1 A2 B1 B2 C1 C2 ZN VDD VNW VPW VSS
.ends

* Black-box entry subcircuit for gf180mcu_fd_sc_mcu7t5v0__antenna abstract view
.subckt gf180mcu_fd_sc_mcu7t5v0__antenna I VDD VNW VPW VSS
.ends

* Black-box entry subcircuit for gf180mcu_fd_sc_mcu7t5v0__aoi21_1 abstract view
.subckt gf180mcu_fd_sc_mcu7t5v0__aoi21_1 A1 A2 B ZN VDD VNW VPW VSS
.ends

* Black-box entry subcircuit for gf180mcu_fd_sc_mcu7t5v0__nand4_2 abstract view
.subckt gf180mcu_fd_sc_mcu7t5v0__nand4_2 A1 A2 A3 A4 ZN VDD VNW VPW VSS
.ends

* Black-box entry subcircuit for gf180mcu_fd_sc_mcu7t5v0__nor3_2 abstract view
.subckt gf180mcu_fd_sc_mcu7t5v0__nor3_2 A1 A2 A3 ZN VDD VNW VPW VSS
.ends

* Black-box entry subcircuit for gf180mcu_fd_sc_mcu7t5v0__and3_1 abstract view
.subckt gf180mcu_fd_sc_mcu7t5v0__and3_1 A1 A2 A3 Z VDD VNW VPW VSS
.ends

* Black-box entry subcircuit for gf180mcu_fd_sc_mcu7t5v0__aoi22_2 abstract view
.subckt gf180mcu_fd_sc_mcu7t5v0__aoi22_2 A1 A2 B1 B2 ZN VDD VNW VPW VSS
.ends

* Black-box entry subcircuit for gf180mcu_fd_sc_mcu7t5v0__dlyb_1 abstract view
.subckt gf180mcu_fd_sc_mcu7t5v0__dlyb_1 I Z VDD VNW VPW VSS
.ends

* Black-box entry subcircuit for gf180mcu_fd_sc_mcu7t5v0__xor2_1 abstract view
.subckt gf180mcu_fd_sc_mcu7t5v0__xor2_1 A1 A2 Z VDD VNW VPW VSS
.ends

* Black-box entry subcircuit for gf180mcu_fd_sc_mcu7t5v0__clkbuf_16 abstract view
.subckt gf180mcu_fd_sc_mcu7t5v0__clkbuf_16 I Z VDD VNW VPW VSS
.ends

* Black-box entry subcircuit for gf180mcu_fd_sc_mcu7t5v0__oai21_1 abstract view
.subckt gf180mcu_fd_sc_mcu7t5v0__oai21_1 A1 A2 B ZN VDD VNW VPW VSS
.ends

* Black-box entry subcircuit for gf180mcu_fd_sc_mcu7t5v0__inv_1 abstract view
.subckt gf180mcu_fd_sc_mcu7t5v0__inv_1 I ZN VDD VNW VPW VSS
.ends

* Black-box entry subcircuit for gf180mcu_fd_sc_mcu7t5v0__clkbuf_8 abstract view
.subckt gf180mcu_fd_sc_mcu7t5v0__clkbuf_8 I Z VDD VNW VPW VSS
.ends

* Black-box entry subcircuit for gf180mcu_fd_sc_mcu7t5v0__or2_1 abstract view
.subckt gf180mcu_fd_sc_mcu7t5v0__or2_1 A1 A2 Z VDD VNW VPW VSS
.ends

* Black-box entry subcircuit for gf180mcu_fd_sc_mcu7t5v0__and2_2 abstract view
.subckt gf180mcu_fd_sc_mcu7t5v0__and2_2 A1 A2 Z VDD VNW VPW VSS
.ends

* Black-box entry subcircuit for gf180mcu_fd_sc_mcu7t5v0__or4_2 abstract view
.subckt gf180mcu_fd_sc_mcu7t5v0__or4_2 A1 A2 A3 A4 Z VDD VNW VPW VSS
.ends

* Black-box entry subcircuit for gf180mcu_fd_sc_mcu7t5v0__xnor2_1 abstract view
.subckt gf180mcu_fd_sc_mcu7t5v0__xnor2_1 A1 A2 ZN VDD VNW VPW VSS
.ends

* Black-box entry subcircuit for gf180mcu_fd_sc_mcu7t5v0__aoi221_1 abstract view
.subckt gf180mcu_fd_sc_mcu7t5v0__aoi221_1 A1 A2 B1 B2 C ZN VDD VNW VPW VSS
.ends

* Black-box entry subcircuit for gf180mcu_fd_sc_mcu7t5v0__oai21_4 abstract view
.subckt gf180mcu_fd_sc_mcu7t5v0__oai21_4 A1 A2 B ZN VDD VNW VPW VSS
.ends

* Black-box entry subcircuit for gf180mcu_fd_sc_mcu7t5v0__xor2_2 abstract view
.subckt gf180mcu_fd_sc_mcu7t5v0__xor2_2 A1 A2 Z VDD VNW VPW VSS
.ends

* Black-box entry subcircuit for gf180mcu_fd_sc_mcu7t5v0__aoi211_1 abstract view
.subckt gf180mcu_fd_sc_mcu7t5v0__aoi211_1 A1 A2 B C ZN VDD VNW VPW VSS
.ends

* Black-box entry subcircuit for gf180mcu_fd_sc_mcu7t5v0__oai211_1 abstract view
.subckt gf180mcu_fd_sc_mcu7t5v0__oai211_1 A1 A2 B C ZN VDD VNW VPW VSS
.ends

* Black-box entry subcircuit for gf180mcu_fd_sc_mcu7t5v0__and4_1 abstract view
.subckt gf180mcu_fd_sc_mcu7t5v0__and4_1 A1 A2 A3 A4 Z VDD VNW VPW VSS
.ends

* Black-box entry subcircuit for gf180mcu_fd_sc_mcu7t5v0__clkbuf_2 abstract view
.subckt gf180mcu_fd_sc_mcu7t5v0__clkbuf_2 I Z VDD VNW VPW VSS
.ends

* Black-box entry subcircuit for gf180mcu_fd_sc_mcu7t5v0__inv_4 abstract view
.subckt gf180mcu_fd_sc_mcu7t5v0__inv_4 I ZN VDD VNW VPW VSS
.ends

* Black-box entry subcircuit for gf180mcu_fd_sc_mcu7t5v0__oai31_1 abstract view
.subckt gf180mcu_fd_sc_mcu7t5v0__oai31_1 A1 A2 A3 B ZN VDD VNW VPW VSS
.ends

* Black-box entry subcircuit for gf180mcu_fd_sc_mcu7t5v0__nor4_1 abstract view
.subckt gf180mcu_fd_sc_mcu7t5v0__nor4_1 A1 A2 A3 A4 ZN VDD VNW VPW VSS
.ends

* Black-box entry subcircuit for gf180mcu_fd_sc_mcu7t5v0__oai22_2 abstract view
.subckt gf180mcu_fd_sc_mcu7t5v0__oai22_2 A1 A2 B1 B2 ZN VDD VNW VPW VSS
.ends

* Black-box entry subcircuit for gf180mcu_fd_sc_mcu7t5v0__and2_1 abstract view
.subckt gf180mcu_fd_sc_mcu7t5v0__and2_1 A1 A2 Z VDD VNW VPW VSS
.ends

* Black-box entry subcircuit for gf180mcu_fd_sc_mcu7t5v0__aoi21_2 abstract view
.subckt gf180mcu_fd_sc_mcu7t5v0__aoi21_2 A1 A2 B ZN VDD VNW VPW VSS
.ends

* Black-box entry subcircuit for gf180mcu_fd_sc_mcu7t5v0__nor4_4 abstract view
.subckt gf180mcu_fd_sc_mcu7t5v0__nor4_4 A1 A2 A3 A4 ZN VDD VNW VPW VSS
.ends

* Black-box entry subcircuit for gf180mcu_fd_sc_mcu7t5v0__nand3_2 abstract view
.subckt gf180mcu_fd_sc_mcu7t5v0__nand3_2 A1 A2 A3 ZN VDD VNW VPW VSS
.ends

* Black-box entry subcircuit for gf180mcu_fd_sc_mcu7t5v0__or3_4 abstract view
.subckt gf180mcu_fd_sc_mcu7t5v0__or3_4 A1 A2 A3 Z VDD VNW VPW VSS
.ends

* Black-box entry subcircuit for gf180mcu_fd_sc_mcu7t5v0__or3_2 abstract view
.subckt gf180mcu_fd_sc_mcu7t5v0__or3_2 A1 A2 A3 Z VDD VNW VPW VSS
.ends

* Black-box entry subcircuit for gf180mcu_fd_sc_mcu7t5v0__nand2_2 abstract view
.subckt gf180mcu_fd_sc_mcu7t5v0__nand2_2 A1 A2 ZN VDD VNW VPW VSS
.ends

* Black-box entry subcircuit for gf180mcu_fd_sc_mcu7t5v0__dffsnq_1 abstract view
.subckt gf180mcu_fd_sc_mcu7t5v0__dffsnq_1 D SETN CLK Q VDD VNW VPW VSS
.ends

* Black-box entry subcircuit for gf180mcu_fd_sc_mcu7t5v0__or3_1 abstract view
.subckt gf180mcu_fd_sc_mcu7t5v0__or3_1 A1 A2 A3 Z VDD VNW VPW VSS
.ends

* Black-box entry subcircuit for gf180mcu_fd_sc_mcu7t5v0__clkinv_12 abstract view
.subckt gf180mcu_fd_sc_mcu7t5v0__clkinv_12 I ZN VDD VNW VPW VSS
.ends

* Black-box entry subcircuit for gf180mcu_fd_sc_mcu7t5v0__or2_2 abstract view
.subckt gf180mcu_fd_sc_mcu7t5v0__or2_2 A1 A2 Z VDD VNW VPW VSS
.ends

* Black-box entry subcircuit for gf180mcu_fd_sc_mcu7t5v0__xor3_1 abstract view
.subckt gf180mcu_fd_sc_mcu7t5v0__xor3_1 A1 A2 A3 Z VDD VNW VPW VSS
.ends

* Black-box entry subcircuit for gf180mcu_fd_sc_mcu7t5v0__aoi22_1 abstract view
.subckt gf180mcu_fd_sc_mcu7t5v0__aoi22_1 A1 A2 B1 B2 ZN VDD VNW VPW VSS
.ends

* Black-box entry subcircuit for gf180mcu_fd_sc_mcu7t5v0__nor2_2 abstract view
.subckt gf180mcu_fd_sc_mcu7t5v0__nor2_2 A1 A2 ZN VDD VNW VPW VSS
.ends

* Black-box entry subcircuit for gf180mcu_fd_sc_mcu7t5v0__oai21_2 abstract view
.subckt gf180mcu_fd_sc_mcu7t5v0__oai21_2 A1 A2 B ZN VDD VNW VPW VSS
.ends

* Black-box entry subcircuit for gf180mcu_fd_sc_mcu7t5v0__clkinv_2 abstract view
.subckt gf180mcu_fd_sc_mcu7t5v0__clkinv_2 I ZN VDD VNW VPW VSS
.ends

* Black-box entry subcircuit for gf180mcu_fd_sc_mcu7t5v0__dffrnq_2 abstract view
.subckt gf180mcu_fd_sc_mcu7t5v0__dffrnq_2 D RN CLK Q VDD VNW VPW VSS
.ends

* Black-box entry subcircuit for gf180mcu_fd_sc_mcu7t5v0__clkinv_4 abstract view
.subckt gf180mcu_fd_sc_mcu7t5v0__clkinv_4 I ZN VDD VNW VPW VSS
.ends

* Black-box entry subcircuit for gf180mcu_fd_sc_mcu7t5v0__inv_2 abstract view
.subckt gf180mcu_fd_sc_mcu7t5v0__inv_2 I ZN VDD VNW VPW VSS
.ends

* Black-box entry subcircuit for gf180mcu_fd_sc_mcu7t5v0__nor4_2 abstract view
.subckt gf180mcu_fd_sc_mcu7t5v0__nor4_2 A1 A2 A3 A4 ZN VDD VNW VPW VSS
.ends

* Black-box entry subcircuit for gf180mcu_fd_sc_mcu7t5v0__clkbuf_4 abstract view
.subckt gf180mcu_fd_sc_mcu7t5v0__clkbuf_4 I Z VDD VNW VPW VSS
.ends

* Black-box entry subcircuit for gf180mcu_fd_sc_mcu7t5v0__buf_8 abstract view
.subckt gf180mcu_fd_sc_mcu7t5v0__buf_8 I Z VDD VNW VPW VSS
.ends

* Black-box entry subcircuit for gf180mcu_fd_sc_mcu7t5v0__oai32_2 abstract view
.subckt gf180mcu_fd_sc_mcu7t5v0__oai32_2 A1 A2 A3 B1 B2 ZN VDD VNW VPW VSS
.ends

* Black-box entry subcircuit for gf180mcu_fd_sc_mcu7t5v0__inv_3 abstract view
.subckt gf180mcu_fd_sc_mcu7t5v0__inv_3 I ZN VDD VNW VPW VSS
.ends

* Black-box entry subcircuit for gf180mcu_fd_sc_mcu7t5v0__aoi22_4 abstract view
.subckt gf180mcu_fd_sc_mcu7t5v0__aoi22_4 A1 A2 B1 B2 ZN VDD VNW VPW VSS
.ends

* Black-box entry subcircuit for gf180mcu_fd_sc_mcu7t5v0__oai221_1 abstract view
.subckt gf180mcu_fd_sc_mcu7t5v0__oai221_1 A1 A2 B1 B2 C ZN VDD VNW VPW VSS
.ends

* Black-box entry subcircuit for gf180mcu_fd_sc_mcu7t5v0__and3_4 abstract view
.subckt gf180mcu_fd_sc_mcu7t5v0__and3_4 A1 A2 A3 Z VDD VNW VPW VSS
.ends

* Black-box entry subcircuit for gf180mcu_fd_sc_mcu7t5v0__and4_2 abstract view
.subckt gf180mcu_fd_sc_mcu7t5v0__and4_2 A1 A2 A3 A4 Z VDD VNW VPW VSS
.ends

* Black-box entry subcircuit for gf180mcu_fd_sc_mcu7t5v0__oai32_1 abstract view
.subckt gf180mcu_fd_sc_mcu7t5v0__oai32_1 A1 A2 A3 B1 B2 ZN VDD VNW VPW VSS
.ends

* Black-box entry subcircuit for gf180mcu_fd_sc_mcu7t5v0__nand2_4 abstract view
.subckt gf180mcu_fd_sc_mcu7t5v0__nand2_4 A1 A2 ZN VDD VNW VPW VSS
.ends

* Black-box entry subcircuit for gf180mcu_fd_sc_mcu7t5v0__and3_2 abstract view
.subckt gf180mcu_fd_sc_mcu7t5v0__and3_2 A1 A2 A3 Z VDD VNW VPW VSS
.ends

* Black-box entry subcircuit for gf180mcu_fd_sc_mcu7t5v0__tiel abstract view
.subckt gf180mcu_fd_sc_mcu7t5v0__tiel ZN VDD VNW VPW VSS
.ends

* Black-box entry subcircuit for gf180mcu_fd_sc_mcu7t5v0__or2_4 abstract view
.subckt gf180mcu_fd_sc_mcu7t5v0__or2_4 A1 A2 Z VDD VNW VPW VSS
.ends

* Black-box entry subcircuit for gf180mcu_fd_sc_mcu7t5v0__and4_4 abstract view
.subckt gf180mcu_fd_sc_mcu7t5v0__and4_4 A1 A2 A3 A4 Z VDD VNW VPW VSS
.ends

* Black-box entry subcircuit for gf180mcu_fd_sc_mcu7t5v0__nor2_4 abstract view
.subckt gf180mcu_fd_sc_mcu7t5v0__nor2_4 A1 A2 ZN VDD VNW VPW VSS
.ends

* Black-box entry subcircuit for gf180mcu_fd_sc_mcu7t5v0__xnor3_1 abstract view
.subckt gf180mcu_fd_sc_mcu7t5v0__xnor3_1 A1 A2 A3 ZN VDD VNW VPW VSS
.ends

* Black-box entry subcircuit for gf180mcu_fd_sc_mcu7t5v0__nor3_4 abstract view
.subckt gf180mcu_fd_sc_mcu7t5v0__nor3_4 A1 A2 A3 ZN VDD VNW VPW VSS
.ends

* Black-box entry subcircuit for gf180mcu_fd_sc_mcu7t5v0__or4_4 abstract view
.subckt gf180mcu_fd_sc_mcu7t5v0__or4_4 A1 A2 A3 A4 Z VDD VNW VPW VSS
.ends

* Black-box entry subcircuit for gf180mcu_fd_sc_mcu7t5v0__buf_20 abstract view
.subckt gf180mcu_fd_sc_mcu7t5v0__buf_20 I Z VDD VNW VPW VSS
.ends

* Black-box entry subcircuit for gf180mcu_fd_sc_mcu7t5v0__or4_1 abstract view
.subckt gf180mcu_fd_sc_mcu7t5v0__or4_1 A1 A2 A3 A4 Z VDD VNW VPW VSS
.ends

* Black-box entry subcircuit for gf180mcu_fd_sc_mcu7t5v0__aoi221_2 abstract view
.subckt gf180mcu_fd_sc_mcu7t5v0__aoi221_2 A1 A2 B1 B2 C ZN VDD VNW VPW VSS
.ends

* Black-box entry subcircuit for gf180mcu_fd_sc_mcu7t5v0__aoi211_4 abstract view
.subckt gf180mcu_fd_sc_mcu7t5v0__aoi211_4 A1 A2 B C ZN VDD VNW VPW VSS
.ends

* Black-box entry subcircuit for gf180mcu_fd_sc_mcu7t5v0__aoi221_4 abstract view
.subckt gf180mcu_fd_sc_mcu7t5v0__aoi221_4 A1 A2 B1 B2 C ZN VDD VNW VPW VSS
.ends

.subckt az_v_uart_top VDD VSS clk irq rst_n s_axi_araddr[0] s_axi_araddr[10] s_axi_araddr[11]
+ s_axi_araddr[12] s_axi_araddr[13] s_axi_araddr[14] s_axi_araddr[15] s_axi_araddr[16]
+ s_axi_araddr[17] s_axi_araddr[18] s_axi_araddr[19] s_axi_araddr[1] s_axi_araddr[20]
+ s_axi_araddr[21] s_axi_araddr[22] s_axi_araddr[23] s_axi_araddr[24] s_axi_araddr[25]
+ s_axi_araddr[26] s_axi_araddr[27] s_axi_araddr[28] s_axi_araddr[29] s_axi_araddr[2]
+ s_axi_araddr[30] s_axi_araddr[31] s_axi_araddr[3] s_axi_araddr[4] s_axi_araddr[5]
+ s_axi_araddr[6] s_axi_araddr[7] s_axi_araddr[8] s_axi_araddr[9] s_axi_arprot[0]
+ s_axi_arprot[1] s_axi_arprot[2] s_axi_arready s_axi_arvalid s_axi_awaddr[0] s_axi_awaddr[10]
+ s_axi_awaddr[11] s_axi_awaddr[12] s_axi_awaddr[13] s_axi_awaddr[14] s_axi_awaddr[15]
+ s_axi_awaddr[16] s_axi_awaddr[17] s_axi_awaddr[18] s_axi_awaddr[19] s_axi_awaddr[1]
+ s_axi_awaddr[20] s_axi_awaddr[21] s_axi_awaddr[22] s_axi_awaddr[23] s_axi_awaddr[24]
+ s_axi_awaddr[25] s_axi_awaddr[26] s_axi_awaddr[27] s_axi_awaddr[28] s_axi_awaddr[29]
+ s_axi_awaddr[2] s_axi_awaddr[30] s_axi_awaddr[31] s_axi_awaddr[3] s_axi_awaddr[4]
+ s_axi_awaddr[5] s_axi_awaddr[6] s_axi_awaddr[7] s_axi_awaddr[8] s_axi_awaddr[9]
+ s_axi_awprot[0] s_axi_awprot[1] s_axi_awprot[2] s_axi_awready s_axi_awvalid s_axi_bready
+ s_axi_bresp[0] s_axi_bresp[1] s_axi_bvalid s_axi_rdata[0] s_axi_rdata[10] s_axi_rdata[11]
+ s_axi_rdata[12] s_axi_rdata[13] s_axi_rdata[14] s_axi_rdata[15] s_axi_rdata[16]
+ s_axi_rdata[17] s_axi_rdata[18] s_axi_rdata[19] s_axi_rdata[1] s_axi_rdata[20] s_axi_rdata[21]
+ s_axi_rdata[22] s_axi_rdata[23] s_axi_rdata[24] s_axi_rdata[25] s_axi_rdata[26]
+ s_axi_rdata[27] s_axi_rdata[28] s_axi_rdata[29] s_axi_rdata[2] s_axi_rdata[30] s_axi_rdata[31]
+ s_axi_rdata[3] s_axi_rdata[4] s_axi_rdata[5] s_axi_rdata[6] s_axi_rdata[7] s_axi_rdata[8]
+ s_axi_rdata[9] s_axi_rready s_axi_rresp[0] s_axi_rresp[1] s_axi_rvalid s_axi_wdata[0]
+ s_axi_wdata[10] s_axi_wdata[11] s_axi_wdata[12] s_axi_wdata[13] s_axi_wdata[14]
+ s_axi_wdata[15] s_axi_wdata[16] s_axi_wdata[17] s_axi_wdata[18] s_axi_wdata[19]
+ s_axi_wdata[1] s_axi_wdata[20] s_axi_wdata[21] s_axi_wdata[22] s_axi_wdata[23] s_axi_wdata[24]
+ s_axi_wdata[25] s_axi_wdata[26] s_axi_wdata[27] s_axi_wdata[28] s_axi_wdata[29]
+ s_axi_wdata[2] s_axi_wdata[30] s_axi_wdata[31] s_axi_wdata[3] s_axi_wdata[4] s_axi_wdata[5]
+ s_axi_wdata[6] s_axi_wdata[7] s_axi_wdata[8] s_axi_wdata[9] s_axi_wready s_axi_wstrb[0]
+ s_axi_wstrb[1] s_axi_wstrb[2] s_axi_wstrb[3] s_axi_wvalid uart_rx_pin uart_tx_pin
XTAP_TAPCELL_ROW_126_1919 VDD VSS gf180mcu_fd_sc_mcu7t5v0__filltie
X_2106_ _2102_/Z _2103_/Z _2104_/Z _2105_/Z place77/Z _4094_/Q _2106_/Z VDD VDD VSS
+ VSS gf180mcu_fd_sc_mcu7t5v0__mux4_1
X_3086_ _3984_/Q _3086_/I1 _4131_/D _3984_/D VDD VDD VSS VSS gf180mcu_fd_sc_mcu7t5v0__mux2_2
X_2037_ _2013_/Z _2036_/Z _2039_/A2 VDD VDD VSS VSS gf180mcu_fd_sc_mcu7t5v0__nor2_1
XTAP_TAPCELL_ROW_25_607 VDD VSS gf180mcu_fd_sc_mcu7t5v0__filltie
XFILLER_54_247 VDD VDD VSS VSS gf180mcu_fd_sc_mcu7t5v0__fillcap_4
XFILLER_22_100 VDD VDD VSS VSS gf180mcu_fd_sc_mcu7t5v0__fillcap_4
XFILLER_51_932 VDD VDD VSS VSS gf180mcu_fd_sc_mcu7t5v0__fill_2
XTAP_TAPCELL_ROW_85_1395 VDD VSS gf180mcu_fd_sc_mcu7t5v0__filltie
XFILLER_50_420 VDD VDD VSS VSS gf180mcu_fd_sc_mcu7t5v0__fill_2
XPHY_EDGE_ROW_99_Left_232 VDD VSS gf180mcu_fd_sc_mcu7t5v0__endcap
XFILLER_10_317 VDD VDD VSS VSS gf180mcu_fd_sc_mcu7t5v0__fillcap_4
X_3988_ _3988_/D input92/Z _4129_/CLK _3988_/Q VDD VDD VSS VSS gf180mcu_fd_sc_mcu7t5v0__dffrnq_1
XFILLER_50_453 VDD VDD VSS VSS gf180mcu_fd_sc_mcu7t5v0__fill_2
X_2939_ _4036_/Q _3916_/Q _2972_/S _3916_/D VDD VDD VSS VSS gf180mcu_fd_sc_mcu7t5v0__mux2_2
XFILLER_117_772 VDD VDD VSS VSS gf180mcu_fd_sc_mcu7t5v0__fillcap_8
XFILLER_105_912 VDD VDD VSS VSS gf180mcu_fd_sc_mcu7t5v0__fillcap_16
XFILLER_105_901 VDD VDD VSS VSS gf180mcu_fd_sc_mcu7t5v0__fillcap_8
XFILLER_117_44 VDD VDD VSS VSS gf180mcu_fd_sc_mcu7t5v0__fillcap_8
XFILLER_2_516 VDD VDD VSS VSS gf180mcu_fd_sc_mcu7t5v0__fillcap_8
XFILLER_89_133 VDD VDD VSS VSS gf180mcu_fd_sc_mcu7t5v0__fillcap_4
XFILLER_78_807 VDD VDD VSS VSS gf180mcu_fd_sc_mcu7t5v0__fillcap_32
XTAP_TAPCELL_ROW_5_354 VDD VSS gf180mcu_fd_sc_mcu7t5v0__filltie
XFILLER_58_531 VDD VDD VSS VSS gf180mcu_fd_sc_mcu7t5v0__fill_2
XFILLER_58_542 VDD VDD VSS VSS gf180mcu_fd_sc_mcu7t5v0__fillcap_4
XFILLER_58_586 VDD VDD VSS VSS gf180mcu_fd_sc_mcu7t5v0__fillcap_8
XFILLER_85_372 VDD VDD VSS VSS gf180mcu_fd_sc_mcu7t5v0__fill_1
XFILLER_18_439 VDD VDD VSS VSS gf180mcu_fd_sc_mcu7t5v0__fillcap_16
XFILLER_46_737 VDD VDD VSS VSS gf180mcu_fd_sc_mcu7t5v0__fillcap_16
XFILLER_58_597 VDD VDD VSS VSS gf180mcu_fd_sc_mcu7t5v0__fillcap_64
XFILLER_73_578 VDD VDD VSS VSS gf180mcu_fd_sc_mcu7t5v0__fillcap_8
XFILLER_73_556 VDD VDD VSS VSS gf180mcu_fd_sc_mcu7t5v0__fillcap_4
XFILLER_61_718 VDD VDD VSS VSS gf180mcu_fd_sc_mcu7t5v0__fillcap_4
XFILLER_14_667 VDD VDD VSS VSS gf180mcu_fd_sc_mcu7t5v0__fillcap_64
XTAP_TAPCELL_ROW_52_960 VDD VSS gf180mcu_fd_sc_mcu7t5v0__filltie
XFILLER_41_486 VDD VDD VSS VSS gf180mcu_fd_sc_mcu7t5v0__fillcap_4
XFILLER_6_833 VDD VDD VSS VSS gf180mcu_fd_sc_mcu7t5v0__fillcap_32
XFILLER_6_877 VDD VDD VSS VSS gf180mcu_fd_sc_mcu7t5v0__fillcap_32
XFILLER_107_282 VDD VDD VSS VSS gf180mcu_fd_sc_mcu7t5v0__fillcap_16
XFILLER_122_241 VDD VDD VSS VSS gf180mcu_fd_sc_mcu7t5v0__fillcap_4
XFILLER_122_263 VDD VDD VSS VSS gf180mcu_fd_sc_mcu7t5v0__fill_1
XFILLER_68_306 VDD VDD VSS VSS gf180mcu_fd_sc_mcu7t5v0__fillcap_8
XFILLER_68_317 VDD VDD VSS VSS gf180mcu_fd_sc_mcu7t5v0__fillcap_16
XFILLER_122_285 VDD VDD VSS VSS gf180mcu_fd_sc_mcu7t5v0__fillcap_16
XFILLER_49_520 VDD VDD VSS VSS gf180mcu_fd_sc_mcu7t5v0__fillcap_32
XFILLER_67_92 VDD VDD VSS VSS gf180mcu_fd_sc_mcu7t5v0__fill_2
XFILLER_76_383 VDD VDD VSS VSS gf180mcu_fd_sc_mcu7t5v0__fill_2
XFILLER_49_586 VDD VDD VSS VSS gf180mcu_fd_sc_mcu7t5v0__fill_2
XFILLER_36_247 VDD VDD VSS VSS gf180mcu_fd_sc_mcu7t5v0__fillcap_8
XFILLER_91_364 VDD VDD VSS VSS gf180mcu_fd_sc_mcu7t5v0__fillcap_8
XFILLER_33_932 VDD VDD VSS VSS gf180mcu_fd_sc_mcu7t5v0__fill_2
X_3911_ _3911_/D _4157_/RN _3976_/CLK _3911_/Q VDD VDD VSS VSS gf180mcu_fd_sc_mcu7t5v0__dffrnq_1
X_3842_ _3842_/D _4156_/CLK _3842_/Q VDD VDD VSS VSS gf180mcu_fd_sc_mcu7t5v0__dffq_1
XFILLER_9_671 VDD VDD VSS VSS gf180mcu_fd_sc_mcu7t5v0__fillcap_16
XFILLER_20_659 VDD VDD VSS VSS gf180mcu_fd_sc_mcu7t5v0__fillcap_4
X_3773_ _3773_/D _3877_/CLK _3773_/Q VDD VDD VSS VSS gf180mcu_fd_sc_mcu7t5v0__dffq_1
X_2724_ _3818_/Q place85/Z _2728_/S _3818_/D VDD VDD VSS VSS gf180mcu_fd_sc_mcu7t5v0__mux2_2
XTAP_TAPCELL_ROW_30_676 VDD VSS gf180mcu_fd_sc_mcu7t5v0__filltie
XFILLER_114_731 VDD VDD VSS VSS gf180mcu_fd_sc_mcu7t5v0__fillcap_4
XFILLER_113_241 VDD VDD VSS VSS gf180mcu_fd_sc_mcu7t5v0__fill_1
X_2586_ _3758_/Q place89/Z _2598_/S _3758_/D VDD VDD VSS VSS gf180mcu_fd_sc_mcu7t5v0__mux2_2
XFILLER_87_626 VDD VDD VSS VSS gf180mcu_fd_sc_mcu7t5v0__fillcap_4
XFILLER_86_125 VDD VDD VSS VSS gf180mcu_fd_sc_mcu7t5v0__fillcap_32
XFILLER_68_851 VDD VDD VSS VSS gf180mcu_fd_sc_mcu7t5v0__fillcap_16
XTAP_TAPCELL_ROW_2_313 VDD VSS gf180mcu_fd_sc_mcu7t5v0__filltie
XFILLER_28_715 VDD VDD VSS VSS gf180mcu_fd_sc_mcu7t5v0__fillcap_16
X_3138_ _4009_/Q _3138_/I1 _3160_/S _4009_/D VDD VDD VSS VSS gf180mcu_fd_sc_mcu7t5v0__mux2_2
XTAP_TAPCELL_ROW_87_1413 VDD VSS gf180mcu_fd_sc_mcu7t5v0__filltie
XFILLER_28_737 VDD VDD VSS VSS gf180mcu_fd_sc_mcu7t5v0__fillcap_16
XFILLER_55_534 VDD VDD VSS VSS gf180mcu_fd_sc_mcu7t5v0__fillcap_8
XFILLER_43_718 VDD VDD VSS VSS gf180mcu_fd_sc_mcu7t5v0__fillcap_4
X_3069_ _4038_/Q _3975_/Q _3081_/S _3975_/D VDD VDD VSS VSS gf180mcu_fd_sc_mcu7t5v0__mux2_2
XTAP_TAPCELL_ROW_38_776 VDD VSS gf180mcu_fd_sc_mcu7t5v0__filltie
XFILLER_24_932 VDD VDD VSS VSS gf180mcu_fd_sc_mcu7t5v0__fill_2
XFILLER_42_239 VDD VDD VSS VSS gf180mcu_fd_sc_mcu7t5v0__fillcap_4
XFILLER_11_659 VDD VDD VSS VSS gf180mcu_fd_sc_mcu7t5v0__fill_1
XFILLER_6_107 VDD VDD VSS VSS gf180mcu_fd_sc_mcu7t5v0__fillcap_64
XTAP_TAPCELL_ROW_98_1564 VDD VSS gf180mcu_fd_sc_mcu7t5v0__filltie
XFILLER_109_558 VDD VDD VSS VSS gf180mcu_fd_sc_mcu7t5v0__fill_2
XFILLER_2_313 VDD VDD VSS VSS gf180mcu_fd_sc_mcu7t5v0__fill_2
XFILLER_132_550 VDD VDD VSS VSS gf180mcu_fd_sc_mcu7t5v0__fill_1
XFILLER_104_263 VDD VDD VSS VSS gf180mcu_fd_sc_mcu7t5v0__fillcap_4
Xhold192 s_axi_wdata[5] hold192/Z VDD VDD VSS VSS gf180mcu_fd_sc_mcu7t5v0__dlyc_1
XFILLER_77_158 VDD VDD VSS VSS gf180mcu_fd_sc_mcu7t5v0__fill_2
XFILLER_92_139 VDD VDD VSS VSS gf180mcu_fd_sc_mcu7t5v0__fillcap_8
XFILLER_58_383 VDD VDD VSS VSS gf180mcu_fd_sc_mcu7t5v0__fill_2
XFILLER_18_247 VDD VDD VSS VSS gf180mcu_fd_sc_mcu7t5v0__fillcap_8
XTAP_TAPCELL_ROW_107_1671 VDD VSS gf180mcu_fd_sc_mcu7t5v0__filltie
XFILLER_33_206 VDD VDD VSS VSS gf180mcu_fd_sc_mcu7t5v0__fillcap_4
XTAP_TAPCELL_ROW_107_1682 VDD VSS gf180mcu_fd_sc_mcu7t5v0__filltie
XFILLER_15_932 VDD VDD VSS VSS gf180mcu_fd_sc_mcu7t5v0__fill_2
XFILLER_53_72 VDD VDD VSS VSS gf180mcu_fd_sc_mcu7t5v0__fillcap_4
XFILLER_41_261 VDD VDD VSS VSS gf180mcu_fd_sc_mcu7t5v0__fillcap_16
XFILLER_6_630 VDD VDD VSS VSS gf180mcu_fd_sc_mcu7t5v0__fillcap_32
X_2440_ _3696_/Q place81/Z _2448_/S _3696_/D VDD VDD VSS VSS gf180mcu_fd_sc_mcu7t5v0__mux2_2
XTAP_TAPCELL_ROW_58_1036 VDD VSS gf180mcu_fd_sc_mcu7t5v0__filltie
XFILLER_108_591 VDD VDD VSS VSS gf180mcu_fd_sc_mcu7t5v0__fillcap_4
XFILLER_5_184 VDD VDD VSS VSS gf180mcu_fd_sc_mcu7t5v0__fill_1
XTAP_TAPCELL_ROW_71_1203 VDD VSS gf180mcu_fd_sc_mcu7t5v0__filltie
XTAP_TAPCELL_ROW_71_1214 VDD VSS gf180mcu_fd_sc_mcu7t5v0__filltie
X_2371_ _3665_/Q _4071_/Q _2377_/S _3665_/D VDD VDD VSS VSS gf180mcu_fd_sc_mcu7t5v0__mux2_2
XFILLER_69_626 VDD VDD VSS VSS gf180mcu_fd_sc_mcu7t5v0__fillcap_4
XFILLER_78_91 VDD VDD VSS VSS gf180mcu_fd_sc_mcu7t5v0__fillcap_8
X_4110_ _4110_/D _2279_/I _4115_/CLK _4110_/Q VDD VDD VSS VSS gf180mcu_fd_sc_mcu7t5v0__dffrnq_1
X_4041_ _4041_/D input92/Z _4130_/CLK _4041_/Q VDD VDD VSS VSS gf180mcu_fd_sc_mcu7t5v0__dffrnq_1
XFILLER_84_629 VDD VDD VSS VSS gf180mcu_fd_sc_mcu7t5v0__fillcap_16
XFILLER_110_277 VDD VDD VSS VSS gf180mcu_fd_sc_mcu7t5v0__fillcap_32
XFILLER_83_128 VDD VDD VSS VSS gf180mcu_fd_sc_mcu7t5v0__fillcap_8
XFILLER_92_651 VDD VDD VSS VSS gf180mcu_fd_sc_mcu7t5v0__fillcap_4
XFILLER_64_331 VDD VDD VSS VSS gf180mcu_fd_sc_mcu7t5v0__fill_1
XFILLER_92_695 VDD VDD VSS VSS gf180mcu_fd_sc_mcu7t5v0__fillcap_8
XFILLER_37_578 VDD VDD VSS VSS gf180mcu_fd_sc_mcu7t5v0__fill_1
XTAP_TAPCELL_ROW_69_1187 VDD VSS gf180mcu_fd_sc_mcu7t5v0__filltie
XTAP_TAPCELL_ROW_35_735 VDD VSS gf180mcu_fd_sc_mcu7t5v0__filltie
XTAP_TAPCELL_ROW_35_746 VDD VSS gf180mcu_fd_sc_mcu7t5v0__filltie
XTAP_TAPCELL_ROW_82_1354 VDD VSS gf180mcu_fd_sc_mcu7t5v0__filltie
XFILLER_60_592 VDD VDD VSS VSS gf180mcu_fd_sc_mcu7t5v0__fill_2
XTAP_TAPCELL_ROW_15_481 VDD VSS gf180mcu_fd_sc_mcu7t5v0__filltie
X_3825_ _3825_/D _3865_/CLK _3825_/Q VDD VDD VSS VSS gf180mcu_fd_sc_mcu7t5v0__dffq_1
X_3756_ _3756_/D _4157_/CLK _3756_/Q VDD VDD VSS VSS gf180mcu_fd_sc_mcu7t5v0__dffq_1
XFILLER_119_889 VDD VDD VSS VSS gf180mcu_fd_sc_mcu7t5v0__fillcap_16
X_3687_ _3687_/D _3729_/CLK _3687_/Q VDD VDD VSS VSS gf180mcu_fd_sc_mcu7t5v0__dffq_1
X_2638_ place83/Z _3780_/Q _2638_/S _3780_/D VDD VDD VSS VSS gf180mcu_fd_sc_mcu7t5v0__mux2_2
XTAP_TAPCELL_ROW_93_1494 VDD VSS gf180mcu_fd_sc_mcu7t5v0__filltie
XFILLER_87_434 VDD VDD VSS VSS gf180mcu_fd_sc_mcu7t5v0__fill_2
XFILLER_114_34 VDD VDD VSS VSS gf180mcu_fd_sc_mcu7t5v0__fill_1
XFILLER_75_629 VDD VDD VSS VSS gf180mcu_fd_sc_mcu7t5v0__fill_1
XFILLER_114_45 VDD VDD VSS VSS gf180mcu_fd_sc_mcu7t5v0__fill_2
XFILLER_101_277 VDD VDD VSS VSS gf180mcu_fd_sc_mcu7t5v0__fill_2
XFILLER_74_128 VDD VDD VSS VSS gf180mcu_fd_sc_mcu7t5v0__fillcap_32
XFILLER_28_523 VDD VDD VSS VSS gf180mcu_fd_sc_mcu7t5v0__fill_2
XFILLER_74_27 VDD VDD VSS VSS gf180mcu_fd_sc_mcu7t5v0__fillcap_8
XFILLER_82_150 VDD VDD VSS VSS gf180mcu_fd_sc_mcu7t5v0__fillcap_4
XFILLER_43_559 VDD VDD VSS VSS gf180mcu_fd_sc_mcu7t5v0__fill_1
XFILLER_30_209 VDD VDD VSS VSS gf180mcu_fd_sc_mcu7t5v0__fillcap_32
XFILLER_11_489 VDD VDD VSS VSS gf180mcu_fd_sc_mcu7t5v0__fill_1
XFILLER_125_837 VDD VDD VSS VSS gf180mcu_fd_sc_mcu7t5v0__fill_2
XFILLER_124_314 VDD VDD VSS VSS gf180mcu_fd_sc_mcu7t5v0__fill_1
XPHY_EDGE_ROW_36_Left_169 VDD VSS gf180mcu_fd_sc_mcu7t5v0__endcap
XFILLER_97_209 VDD VDD VSS VSS gf180mcu_fd_sc_mcu7t5v0__fill_1
XFILLER_3_666 VDD VDD VSS VSS gf180mcu_fd_sc_mcu7t5v0__fill_1
XFILLER_105_594 VDD VDD VSS VSS gf180mcu_fd_sc_mcu7t5v0__fillcap_16
XTAP_TAPCELL_ROW_109_1700 VDD VSS gf180mcu_fd_sc_mcu7t5v0__filltie
XFILLER_78_489 VDD VDD VSS VSS gf180mcu_fd_sc_mcu7t5v0__fillcap_32
XPHY_EDGE_ROW_45_Left_178 VDD VSS gf180mcu_fd_sc_mcu7t5v0__endcap
XFILLER_47_865 VDD VDD VSS VSS gf180mcu_fd_sc_mcu7t5v0__fillcap_4
XFILLER_65_139 VDD VDD VSS VSS gf180mcu_fd_sc_mcu7t5v0__fill_1
XFILLER_15_762 VDD VDD VSS VSS gf180mcu_fd_sc_mcu7t5v0__fillcap_8
XTAP_TAPCELL_ROW_32_705 VDD VSS gf180mcu_fd_sc_mcu7t5v0__filltie
X_1940_ _2899_/A1 _1940_/A2 _1940_/B _4145_/Q _1943_/A2 VDD VDD VSS VSS gf180mcu_fd_sc_mcu7t5v0__oai211_2
XFILLER_30_732 VDD VDD VSS VSS gf180mcu_fd_sc_mcu7t5v0__fill_2
X_1871_ _3887_/Q _3885_/Q _3886_/Q _1881_/A2 VDD VDD VSS VSS gf180mcu_fd_sc_mcu7t5v0__nor3_1
XFILLER_9_88 VDD VDD VSS VSS gf180mcu_fd_sc_mcu7t5v0__fillcap_4
XFILLER_128_631 VDD VDD VSS VSS gf180mcu_fd_sc_mcu7t5v0__fillcap_16
XPHY_EDGE_ROW_104_Right_104 VDD VSS gf180mcu_fd_sc_mcu7t5v0__endcap
XTAP_TAPCELL_ROW_12_440 VDD VSS gf180mcu_fd_sc_mcu7t5v0__filltie
XPHY_EDGE_ROW_54_Left_187 VDD VSS gf180mcu_fd_sc_mcu7t5v0__endcap
XFILLER_128_664 VDD VDD VSS VSS gf180mcu_fd_sc_mcu7t5v0__fill_1
XFILLER_127_174 VDD VDD VSS VSS gf180mcu_fd_sc_mcu7t5v0__fill_2
XFILLER_115_314 VDD VDD VSS VSS gf180mcu_fd_sc_mcu7t5v0__fillcap_8
XFILLER_131_807 VDD VDD VSS VSS gf180mcu_fd_sc_mcu7t5v0__fillcap_32
X_3472_ _4105_/Q _4106_/Q _3475_/A2 VDD VDD VSS VSS gf180mcu_fd_sc_mcu7t5v0__nand2_1
XFILLER_130_317 VDD VDD VSS VSS gf180mcu_fd_sc_mcu7t5v0__fillcap_32
XFILLER_124_870 VDD VDD VSS VSS gf180mcu_fd_sc_mcu7t5v0__fillcap_4
XFILLER_89_90 VDD VDD VSS VSS gf180mcu_fd_sc_mcu7t5v0__fill_1
XFILLER_43_2 VDD VDD VSS VSS gf180mcu_fd_sc_mcu7t5v0__fill_2
XFILLER_97_787 VDD VDD VSS VSS gf180mcu_fd_sc_mcu7t5v0__fill_2
XFILLER_85_927 VDD VDD VSS VSS gf180mcu_fd_sc_mcu7t5v0__fillcap_4
XPHY_EDGE_ROW_63_Left_196 VDD VSS gf180mcu_fd_sc_mcu7t5v0__endcap
XFILLER_38_854 VDD VDD VSS VSS gf180mcu_fd_sc_mcu7t5v0__fillcap_16
X_4024_ _4024_/D input92/Z _4028_/CLK _4024_/Q VDD VDD VSS VSS gf180mcu_fd_sc_mcu7t5v0__dffrnq_1
XFILLER_53_802 VDD VDD VSS VSS gf180mcu_fd_sc_mcu7t5v0__fillcap_32
XFILLER_12_209 VDD VDD VSS VSS gf180mcu_fd_sc_mcu7t5v0__fillcap_4
XFILLER_21_710 VDD VDD VSS VSS gf180mcu_fd_sc_mcu7t5v0__fillcap_4
XFILLER_20_242 VDD VDD VSS VSS gf180mcu_fd_sc_mcu7t5v0__fill_2
XFILLER_21_743 VDD VDD VSS VSS gf180mcu_fd_sc_mcu7t5v0__fillcap_16
X_3808_ _3808_/D _4129_/CLK _3808_/Q VDD VDD VSS VSS gf180mcu_fd_sc_mcu7t5v0__dffq_1
XFILLER_20_253 VDD VDD VSS VSS gf180mcu_fd_sc_mcu7t5v0__fill_1
XFILLER_119_664 VDD VDD VSS VSS gf180mcu_fd_sc_mcu7t5v0__fillcap_16
XFILLER_107_837 VDD VDD VSS VSS gf180mcu_fd_sc_mcu7t5v0__fill_2
XTAP_TAPCELL_ROW_95_1523 VDD VSS gf180mcu_fd_sc_mcu7t5v0__filltie
X_3739_ _3739_/D _3740_/CLK _3739_/Q VDD VDD VSS VSS gf180mcu_fd_sc_mcu7t5v0__dffq_1
XFILLER_122_807 VDD VDD VSS VSS gf180mcu_fd_sc_mcu7t5v0__fillcap_32
XFILLER_79_209 VDD VDD VSS VSS gf180mcu_fd_sc_mcu7t5v0__fill_1
XFILLER_0_614 VDD VDD VSS VSS gf180mcu_fd_sc_mcu7t5v0__fillcap_32
XFILLER_0_658 VDD VDD VSS VSS gf180mcu_fd_sc_mcu7t5v0__fill_1
XFILLER_102_597 VDD VDD VSS VSS gf180mcu_fd_sc_mcu7t5v0__fill_2
XFILLER_88_798 VDD VDD VSS VSS gf180mcu_fd_sc_mcu7t5v0__fillcap_4
XFILLER_87_264 VDD VDD VSS VSS gf180mcu_fd_sc_mcu7t5v0__fillcap_16
XFILLER_75_437 VDD VDD VSS VSS gf180mcu_fd_sc_mcu7t5v0__fillcap_32
XFILLER_83_492 VDD VDD VSS VSS gf180mcu_fd_sc_mcu7t5v0__fillcap_32
XFILLER_71_632 VDD VDD VSS VSS gf180mcu_fd_sc_mcu7t5v0__fillcap_64
XFILLER_28_397 VDD VDD VSS VSS gf180mcu_fd_sc_mcu7t5v0__fill_1
XTAP_TAPCELL_ROW_104_1641 VDD VSS gf180mcu_fd_sc_mcu7t5v0__filltie
XFILLER_11_220 VDD VDD VSS VSS gf180mcu_fd_sc_mcu7t5v0__fill_1
XFILLER_24_592 VDD VDD VSS VSS gf180mcu_fd_sc_mcu7t5v0__fill_2
XFILLER_125_656 VDD VDD VSS VSS gf180mcu_fd_sc_mcu7t5v0__fill_2
XTAP_TAPCELL_ROW_55_1006 VDD VSS gf180mcu_fd_sc_mcu7t5v0__filltie
XFILLER_124_166 VDD VDD VSS VSS gf180mcu_fd_sc_mcu7t5v0__fillcap_8
XTAP_TAPCELL_ROW_115_1781 VDD VSS gf180mcu_fd_sc_mcu7t5v0__filltie
XFILLER_112_317 VDD VDD VSS VSS gf180mcu_fd_sc_mcu7t5v0__fillcap_16
XFILLER_106_870 VDD VDD VSS VSS gf180mcu_fd_sc_mcu7t5v0__fillcap_4
XFILLER_98_518 VDD VDD VSS VSS gf180mcu_fd_sc_mcu7t5v0__fillcap_4
XFILLER_3_463 VDD VDD VSS VSS gf180mcu_fd_sc_mcu7t5v0__fillcap_16
XFILLER_124_199 VDD VDD VSS VSS gf180mcu_fd_sc_mcu7t5v0__fillcap_4
XFILLER_124_177 VDD VDD VSS VSS gf180mcu_fd_sc_mcu7t5v0__fill_1
XFILLER_59_60 VDD VDD VSS VSS gf180mcu_fd_sc_mcu7t5v0__fillcap_8
XFILLER_79_765 VDD VDD VSS VSS gf180mcu_fd_sc_mcu7t5v0__fillcap_4
XFILLER_93_212 VDD VDD VSS VSS gf180mcu_fd_sc_mcu7t5v0__fillcap_4
X_2070_ place71/Z _2097_/A2 _2097_/A3 _2069_/Z _2072_/A2 VDD VDD VSS VSS gf180mcu_fd_sc_mcu7t5v0__nand4_1
XTAP_TAPCELL_ROW_17_510 VDD VSS gf180mcu_fd_sc_mcu7t5v0__filltie
XFILLER_61_131 VDD VDD VSS VSS gf180mcu_fd_sc_mcu7t5v0__fillcap_8
XFILLER_61_142 VDD VDD VSS VSS gf180mcu_fd_sc_mcu7t5v0__fillcap_16
XTAP_TAPCELL_ROW_66_1146 VDD VSS gf180mcu_fd_sc_mcu7t5v0__filltie
X_2972_ _4052_/Q _3932_/Q _2972_/S _3932_/D VDD VDD VSS VSS gf180mcu_fd_sc_mcu7t5v0__mux2_2
XTAP_TAPCELL_ROW_45_874 VDD VSS gf180mcu_fd_sc_mcu7t5v0__filltie
X_1923_ _1905_/Z _1820_/Z _1822_/Z _1923_/B _1947_/B VDD VDD VSS VSS gf180mcu_fd_sc_mcu7t5v0__oai31_2
X_1854_ _4139_/Q _1855_/B VDD VDD VSS VSS gf180mcu_fd_sc_mcu7t5v0__clkinv_1
XFILLER_128_461 VDD VDD VSS VSS gf180mcu_fd_sc_mcu7t5v0__fill_2
XFILLER_128_450 VDD VDD VSS VSS gf180mcu_fd_sc_mcu7t5v0__fillcap_4
XFILLER_116_667 VDD VDD VSS VSS gf180mcu_fd_sc_mcu7t5v0__fillcap_8
XFILLER_115_166 VDD VDD VSS VSS gf180mcu_fd_sc_mcu7t5v0__fill_1
XFILLER_104_807 VDD VDD VSS VSS gf180mcu_fd_sc_mcu7t5v0__fillcap_64
XTAP_TAPCELL_ROW_77_1286 VDD VSS gf180mcu_fd_sc_mcu7t5v0__filltie
X_3455_ _4104_/Q _3477_/A2 _3452_/B _3457_/A1 VDD VDD VSS VSS gf180mcu_fd_sc_mcu7t5v0__nand3_1
X_2406_ _4071_/Q _3681_/Q _2412_/S _3681_/D VDD VDD VSS VSS gf180mcu_fd_sc_mcu7t5v0__mux2_2
X_3386_ _3391_/A1 _3376_/Z _3382_/B _3389_/A1 _3387_/A2 VDD VDD VSS VSS gf180mcu_fd_sc_mcu7t5v0__oai22_1
XFILLER_97_540 VDD VDD VSS VSS gf180mcu_fd_sc_mcu7t5v0__fillcap_8
XTAP_TAPCELL_ROW_90_1453 VDD VSS gf180mcu_fd_sc_mcu7t5v0__filltie
XFILLER_85_702 VDD VDD VSS VSS gf180mcu_fd_sc_mcu7t5v0__fillcap_8
XPHY_EDGE_ROW_71_Left_204 VDD VSS gf180mcu_fd_sc_mcu7t5v0__endcap
X_2268_ _3929_/Q place72/Z place63/Z _3961_/Q _3969_/Q place67/Z _2269_/I VDD VDD
+ VSS VSS gf180mcu_fd_sc_mcu7t5v0__aoi222_1
XFILLER_85_757 VDD VDD VSS VSS gf180mcu_fd_sc_mcu7t5v0__fillcap_8
X_4007_ _4007_/D _4148_/RN _4136_/CLK _4007_/Q VDD VDD VSS VSS gf180mcu_fd_sc_mcu7t5v0__dffrnq_1
XFILLER_84_267 VDD VDD VSS VSS gf180mcu_fd_sc_mcu7t5v0__fill_2
XFILLER_37_150 VDD VDD VSS VSS gf180mcu_fd_sc_mcu7t5v0__fillcap_4
X_2199_ _3635_/Q _3691_/Q _3699_/Q _3707_/Q place79/Z place78/Z _2199_/Z VDD VDD VSS
+ VSS gf180mcu_fd_sc_mcu7t5v0__mux4_1
XFILLER_53_621 VDD VDD VSS VSS gf180mcu_fd_sc_mcu7t5v0__fillcap_8
XFILLER_65_492 VDD VDD VSS VSS gf180mcu_fd_sc_mcu7t5v0__fillcap_32
XFILLER_111_68 VDD VDD VSS VSS gf180mcu_fd_sc_mcu7t5v0__fill_2
XPHY_EDGE_ROW_80_Left_213 VDD VSS gf180mcu_fd_sc_mcu7t5v0__endcap
XFILLER_21_562 VDD VDD VSS VSS gf180mcu_fd_sc_mcu7t5v0__fillcap_64
XTAP_TAPCELL_ROW_23_579 VDD VSS gf180mcu_fd_sc_mcu7t5v0__filltie
XFILLER_106_100 VDD VDD VSS VSS gf180mcu_fd_sc_mcu7t5v0__fillcap_4
XFILLER_1_912 VDD VDD VSS VSS gf180mcu_fd_sc_mcu7t5v0__fillcap_16
XFILLER_20_98 VDD VDD VSS VSS gf180mcu_fd_sc_mcu7t5v0__fillcap_4
XFILLER_0_444 VDD VDD VSS VSS gf180mcu_fd_sc_mcu7t5v0__fillcap_16
XFILLER_75_212 VDD VDD VSS VSS gf180mcu_fd_sc_mcu7t5v0__fillcap_8
XFILLER_48_415 VDD VDD VSS VSS gf180mcu_fd_sc_mcu7t5v0__fill_1
XFILLER_29_96 VDD VDD VSS VSS gf180mcu_fd_sc_mcu7t5v0__fillcap_4
XFILLER_75_278 VDD VDD VSS VSS gf180mcu_fd_sc_mcu7t5v0__fill_2
XFILLER_63_418 VDD VDD VSS VSS gf180mcu_fd_sc_mcu7t5v0__fill_2
XFILLER_17_846 VDD VDD VSS VSS gf180mcu_fd_sc_mcu7t5v0__fill_2
XPHY_EDGE_ROW_119_Left_252 VDD VSS gf180mcu_fd_sc_mcu7t5v0__endcap
XFILLER_43_142 VDD VDD VSS VSS gf180mcu_fd_sc_mcu7t5v0__fillcap_64
XFILLER_71_462 VDD VDD VSS VSS gf180mcu_fd_sc_mcu7t5v0__fillcap_4
XFILLER_71_484 VDD VDD VSS VSS gf180mcu_fd_sc_mcu7t5v0__fillcap_4
XFILLER_31_326 VDD VDD VSS VSS gf180mcu_fd_sc_mcu7t5v0__fill_1
XTAP_TAPCELL_ROW_42_833 VDD VSS gf180mcu_fd_sc_mcu7t5v0__filltie
XFILLER_129_203 VDD VDD VSS VSS gf180mcu_fd_sc_mcu7t5v0__fillcap_4
XFILLER_40_871 VDD VDD VSS VSS gf180mcu_fd_sc_mcu7t5v0__fillcap_4
XFILLER_129_236 VDD VDD VSS VSS gf180mcu_fd_sc_mcu7t5v0__fillcap_4
XFILLER_12_584 VDD VDD VSS VSS gf180mcu_fd_sc_mcu7t5v0__fillcap_8
XFILLER_61_72 VDD VDD VSS VSS gf180mcu_fd_sc_mcu7t5v0__fill_1
XTAP_TAPCELL_ROW_61_1076 VDD VSS gf180mcu_fd_sc_mcu7t5v0__filltie
XTAP_TAPCELL_ROW_117_1810 VDD VSS gf180mcu_fd_sc_mcu7t5v0__filltie
XFILLER_6_34 VDD VDD VSS VSS gf180mcu_fd_sc_mcu7t5v0__fill_1
XANTENNA_5 _2208_/ZN VDD VDD VSS VSS gf180mcu_fd_sc_mcu7t5v0__antenna
XPHY_EDGE_ROW_128_Left_261 VDD VSS gf180mcu_fd_sc_mcu7t5v0__endcap
XFILLER_6_67 VDD VDD VSS VSS gf180mcu_fd_sc_mcu7t5v0__fill_1
XFILLER_98_359 VDD VDD VSS VSS gf180mcu_fd_sc_mcu7t5v0__fill_1
XFILLER_3_282 VDD VDD VSS VSS gf180mcu_fd_sc_mcu7t5v0__fillcap_8
XFILLER_79_562 VDD VDD VSS VSS gf180mcu_fd_sc_mcu7t5v0__fillcap_64
X_3171_ place86/Z _3993_/Q _4129_/D _4025_/D VDD VDD VSS VSS gf180mcu_fd_sc_mcu7t5v0__mux2_2
XFILLER_67_702 VDD VDD VSS VSS gf180mcu_fd_sc_mcu7t5v0__fillcap_64
X_2122_ _2122_/A1 _2122_/A2 _2219_/B _2123_/C VDD VDD VSS VSS gf180mcu_fd_sc_mcu7t5v0__aoi21_1
XTAP_TAPCELL_ROW_128_1950 VDD VSS gf180mcu_fd_sc_mcu7t5v0__filltie
XFILLER_82_727 VDD VDD VSS VSS gf180mcu_fd_sc_mcu7t5v0__fillcap_8
X_2053_ place71/Z _2097_/A2 _2097_/A3 _2052_/Z _2055_/A2 VDD VDD VSS VSS gf180mcu_fd_sc_mcu7t5v0__nand4_2
XFILLER_35_632 VDD VDD VSS VSS gf180mcu_fd_sc_mcu7t5v0__fillcap_16
XFILLER_47_492 VDD VDD VSS VSS gf180mcu_fd_sc_mcu7t5v0__fillcap_4
X_1906_ _1905_/Z _1820_/Z _1822_/Z _1907_/C VDD VDD VSS VSS gf180mcu_fd_sc_mcu7t5v0__nor3_2
X_2886_ place84/Z _2900_/S _2887_/B VDD VDD VSS VSS gf180mcu_fd_sc_mcu7t5v0__nand2_1
XTAP_TAPCELL_ROW_79_1315 VDD VSS gf180mcu_fd_sc_mcu7t5v0__filltie
X_1837_ _3897_/Q _1837_/A2 _1837_/A3 _1837_/Z VDD VDD VSS VSS gf180mcu_fd_sc_mcu7t5v0__and3_1
XTAP_TAPCELL_ROW_20_549 VDD VSS gf180mcu_fd_sc_mcu7t5v0__filltie
XFILLER_116_453 VDD VDD VSS VSS gf180mcu_fd_sc_mcu7t5v0__fill_2
X_3507_ _4110_/Q _4111_/Q _3509_/B1 VDD VDD VSS VSS gf180mcu_fd_sc_mcu7t5v0__nand2_1
XFILLER_103_114 VDD VDD VSS VSS gf180mcu_fd_sc_mcu7t5v0__fillcap_16
X_3438_ _3438_/A1 _3444_/A1 _3447_/A2 _3441_/A2 _4099_/D VDD VDD VSS VSS gf180mcu_fd_sc_mcu7t5v0__aoi22_2
XFILLER_131_489 VDD VDD VSS VSS gf180mcu_fd_sc_mcu7t5v0__fill_1
XFILLER_98_871 VDD VDD VSS VSS gf180mcu_fd_sc_mcu7t5v0__fillcap_4
XFILLER_85_510 VDD VDD VSS VSS gf180mcu_fd_sc_mcu7t5v0__fill_1
X_3369_ _1952_/Z _3316_/Z _3370_/A2 VDD VDD VSS VSS gf180mcu_fd_sc_mcu7t5v0__nor2_1
XFILLER_85_543 VDD VDD VSS VSS gf180mcu_fd_sc_mcu7t5v0__fill_1
XFILLER_57_212 VDD VDD VSS VSS gf180mcu_fd_sc_mcu7t5v0__fillcap_64
XFILLER_122_23 VDD VDD VSS VSS gf180mcu_fd_sc_mcu7t5v0__fillcap_8
XFILLER_46_919 VDD VDD VSS VSS gf180mcu_fd_sc_mcu7t5v0__fillcap_8
XFILLER_26_610 VDD VDD VSS VSS gf180mcu_fd_sc_mcu7t5v0__fillcap_32
XFILLER_38_481 VDD VDD VSS VSS gf180mcu_fd_sc_mcu7t5v0__fill_1
XFILLER_82_27 VDD VDD VSS VSS gf180mcu_fd_sc_mcu7t5v0__fillcap_8
XFILLER_25_142 VDD VDD VSS VSS gf180mcu_fd_sc_mcu7t5v0__fillcap_64
XTAP_TAPCELL_ROW_28_649 VDD VSS gf180mcu_fd_sc_mcu7t5v0__filltie
XTAP_TAPCELL_ROW_101_1600 VDD VSS gf180mcu_fd_sc_mcu7t5v0__filltie
XTAP_TAPCELL_ROW_0_274 VDD VSS gf180mcu_fd_sc_mcu7t5v0__filltie
XTAP_TAPCELL_ROW_0_285 VDD VSS gf180mcu_fd_sc_mcu7t5v0__filltie
XFILLER_80_292 VDD VDD VSS VSS gf180mcu_fd_sc_mcu7t5v0__fillcap_16
XFILLER_15_87 VDD VDD VSS VSS gf180mcu_fd_sc_mcu7t5v0__fillcap_32
XFILLER_126_206 VDD VDD VSS VSS gf180mcu_fd_sc_mcu7t5v0__fill_2
XFILLER_122_401 VDD VDD VSS VSS gf180mcu_fd_sc_mcu7t5v0__fill_2
XFILLER_107_486 VDD VDD VSS VSS gf180mcu_fd_sc_mcu7t5v0__fillcap_4
XTAP_TAPCELL_ROW_112_1740 VDD VSS gf180mcu_fd_sc_mcu7t5v0__filltie
XTAP_TAPCELL_ROW_8_396 VDD VSS gf180mcu_fd_sc_mcu7t5v0__filltie
XTAP_TAPCELL_ROW_8_385 VDD VSS gf180mcu_fd_sc_mcu7t5v0__filltie
XFILLER_49_702 VDD VDD VSS VSS gf180mcu_fd_sc_mcu7t5v0__fillcap_64
Xinput120 hold196/Z _3098_/I1 VDD VDD VSS VSS gf180mcu_fd_sc_mcu7t5v0__dlyb_1
Xinput142 hold210/Z _1996_/I0 VDD VDD VSS VSS gf180mcu_fd_sc_mcu7t5v0__dlyb_1
XFILLER_0_274 VDD VDD VSS VSS gf180mcu_fd_sc_mcu7t5v0__fill_1
Xinput131 hold191/Z _3100_/I1 VDD VDD VSS VSS gf180mcu_fd_sc_mcu7t5v0__dlyb_1
XTAP_TAPCELL_ROW_47_903 VDD VSS gf180mcu_fd_sc_mcu7t5v0__filltie
XFILLER_64_727 VDD VDD VSS VSS gf180mcu_fd_sc_mcu7t5v0__fillcap_8
XFILLER_91_524 VDD VDD VSS VSS gf180mcu_fd_sc_mcu7t5v0__fill_1
XFILLER_17_632 VDD VDD VSS VSS gf180mcu_fd_sc_mcu7t5v0__fillcap_64
XFILLER_32_613 VDD VDD VSS VSS gf180mcu_fd_sc_mcu7t5v0__fill_1
XFILLER_44_473 VDD VDD VSS VSS gf180mcu_fd_sc_mcu7t5v0__fillcap_4
XFILLER_60_933 VDD VDD VSS VSS gf180mcu_fd_sc_mcu7t5v0__fill_1
XTAP_TAPCELL_ROW_63_1105 VDD VSS gf180mcu_fd_sc_mcu7t5v0__filltie
XTAP_TAPCELL_ROW_123_1891 VDD VSS gf180mcu_fd_sc_mcu7t5v0__filltie
XTAP_TAPCELL_ROW_123_1880 VDD VSS gf180mcu_fd_sc_mcu7t5v0__filltie
XFILLER_13_871 VDD VDD VSS VSS gf180mcu_fd_sc_mcu7t5v0__fillcap_8
X_2740_ _3825_/Q place86/Z _2746_/S _3825_/D VDD VDD VSS VSS gf180mcu_fd_sc_mcu7t5v0__mux2_2
XFILLER_9_842 VDD VDD VSS VSS gf180mcu_fd_sc_mcu7t5v0__fillcap_64
XFILLER_117_206 VDD VDD VSS VSS gf180mcu_fd_sc_mcu7t5v0__fillcap_4
XFILLER_99_613 VDD VDD VSS VSS gf180mcu_fd_sc_mcu7t5v0__fill_2
XFILLER_98_101 VDD VDD VSS VSS gf180mcu_fd_sc_mcu7t5v0__fillcap_4
XTAP_TAPCELL_ROW_74_1245 VDD VSS gf180mcu_fd_sc_mcu7t5v0__filltie
X_3223_ _4050_/Q _4018_/Q _4129_/D _4050_/D VDD VDD VSS VSS gf180mcu_fd_sc_mcu7t5v0__mux2_2
XFILLER_113_489 VDD VDD VSS VSS gf180mcu_fd_sc_mcu7t5v0__fill_1
XFILLER_86_329 VDD VDD VSS VSS gf180mcu_fd_sc_mcu7t5v0__fill_1
XFILLER_100_139 VDD VDD VSS VSS gf180mcu_fd_sc_mcu7t5v0__fillcap_8
XFILLER_39_212 VDD VDD VSS VSS gf180mcu_fd_sc_mcu7t5v0__fillcap_8
X_3154_ _4017_/Q _3154_/I1 _3160_/S _4017_/D VDD VDD VSS VSS gf180mcu_fd_sc_mcu7t5v0__mux2_2
XFILLER_27_407 VDD VDD VSS VSS gf180mcu_fd_sc_mcu7t5v0__fillcap_8
XFILLER_39_256 VDD VDD VSS VSS gf180mcu_fd_sc_mcu7t5v0__fillcap_8
X_2105_ _3653_/Q _3661_/Q _3669_/Q _3677_/Q place79/Z place78/Z _2105_/Z VDD VDD VSS
+ VSS gf180mcu_fd_sc_mcu7t5v0__mux4_1
XFILLER_54_226 VDD VDD VSS VSS gf180mcu_fd_sc_mcu7t5v0__fillcap_4
X_2036_ _4136_/Q _2079_/A2 _2036_/Z VDD VDD VSS VSS gf180mcu_fd_sc_mcu7t5v0__xor2_1
XFILLER_23_613 VDD VDD VSS VSS gf180mcu_fd_sc_mcu7t5v0__fillcap_16
XTAP_TAPCELL_ROW_25_608 VDD VSS gf180mcu_fd_sc_mcu7t5v0__filltie
XFILLER_35_484 VDD VDD VSS VSS gf180mcu_fd_sc_mcu7t5v0__fillcap_4
XTAP_TAPCELL_ROW_85_1396 VDD VSS gf180mcu_fd_sc_mcu7t5v0__filltie
XTAP_TAPCELL_ROW_85_1385 VDD VSS gf180mcu_fd_sc_mcu7t5v0__filltie
XFILLER_22_145 VDD VDD VSS VSS gf180mcu_fd_sc_mcu7t5v0__fill_1
X_3987_ _3987_/D input92/Z clkload9/I _3987_/Q VDD VDD VSS VSS gf180mcu_fd_sc_mcu7t5v0__dffrnq_1
X_2869_ _4055_/Q _3519_/A2 _2870_/A3 VDD VDD VSS VSS gf180mcu_fd_sc_mcu7t5v0__nand2_1
XFILLER_117_784 VDD VDD VSS VSS gf180mcu_fd_sc_mcu7t5v0__fill_1
XFILLER_132_743 VDD VDD VSS VSS gf180mcu_fd_sc_mcu7t5v0__fillcap_4
XFILLER_120_927 VDD VDD VSS VSS gf180mcu_fd_sc_mcu7t5v0__fillcap_4
XTAP_TAPCELL_ROW_5_355 VDD VSS gf180mcu_fd_sc_mcu7t5v0__filltie
XFILLER_18_407 VDD VDD VSS VSS gf180mcu_fd_sc_mcu7t5v0__fillcap_32
XFILLER_58_576 VDD VDD VSS VSS gf180mcu_fd_sc_mcu7t5v0__fill_2
Xclkbuf_3_6__f_clk clkbuf_0_clk/Z clkload5/I VDD VDD VSS VSS gf180mcu_fd_sc_mcu7t5v0__clkbuf_16
XFILLER_26_451 VDD VDD VSS VSS gf180mcu_fd_sc_mcu7t5v0__fillcap_4
XFILLER_42_933 VDD VDD VSS VSS gf180mcu_fd_sc_mcu7t5v0__fill_1
XTAP_TAPCELL_ROW_52_961 VDD VSS gf180mcu_fd_sc_mcu7t5v0__filltie
XFILLER_10_863 VDD VDD VSS VSS gf180mcu_fd_sc_mcu7t5v0__fillcap_8
XFILLER_42_96 VDD VDD VSS VSS gf180mcu_fd_sc_mcu7t5v0__fillcap_8
XFILLER_127_559 VDD VDD VSS VSS gf180mcu_fd_sc_mcu7t5v0__fill_1
XFILLER_114_209 VDD VDD VSS VSS gf180mcu_fd_sc_mcu7t5v0__fill_2
XFILLER_5_344 VDD VDD VSS VSS gf180mcu_fd_sc_mcu7t5v0__fillcap_4
XFILLER_108_773 VDD VDD VSS VSS gf180mcu_fd_sc_mcu7t5v0__fillcap_32
XFILLER_76_395 VDD VDD VSS VSS gf180mcu_fd_sc_mcu7t5v0__fill_2
XFILLER_37_749 VDD VDD VSS VSS gf180mcu_fd_sc_mcu7t5v0__fillcap_16
XFILLER_92_855 VDD VDD VSS VSS gf180mcu_fd_sc_mcu7t5v0__fill_1
X_3910_ _3910_/D _4157_/RN _3976_/CLK _3910_/Q VDD VDD VSS VSS gf180mcu_fd_sc_mcu7t5v0__dffrnq_1
XFILLER_72_590 VDD VDD VSS VSS gf180mcu_fd_sc_mcu7t5v0__fillcap_4
X_3841_ _3841_/D _3865_/CLK _3841_/Q VDD VDD VSS VSS gf180mcu_fd_sc_mcu7t5v0__dffq_1
X_3772_ _3772_/D _4023_/CLK _3772_/Q VDD VDD VSS VSS gf180mcu_fd_sc_mcu7t5v0__dffq_1
XFILLER_73_2 VDD VDD VSS VSS gf180mcu_fd_sc_mcu7t5v0__fill_2
XFILLER_8_171 VDD VDD VSS VSS gf180mcu_fd_sc_mcu7t5v0__fillcap_4
XTAP_TAPCELL_ROW_30_677 VDD VSS gf180mcu_fd_sc_mcu7t5v0__filltie
X_2654_ place85/Z _3786_/Q _2658_/S _3786_/D VDD VDD VSS VSS gf180mcu_fd_sc_mcu7t5v0__mux2_2
XFILLER_105_209 VDD VDD VSS VSS gf180mcu_fd_sc_mcu7t5v0__fill_1
XFILLER_99_454 VDD VDD VSS VSS gf180mcu_fd_sc_mcu7t5v0__fillcap_4
X_3206_ _4042_/Q _4010_/Q _4129_/D _4042_/D VDD VDD VSS VSS gf180mcu_fd_sc_mcu7t5v0__mux2_2
XTAP_TAPCELL_ROW_2_314 VDD VSS gf180mcu_fd_sc_mcu7t5v0__filltie
XTAP_TAPCELL_ROW_87_1414 VDD VSS gf180mcu_fd_sc_mcu7t5v0__filltie
XFILLER_67_384 VDD VDD VSS VSS gf180mcu_fd_sc_mcu7t5v0__fillcap_16
XFILLER_103_58 VDD VDD VSS VSS gf180mcu_fd_sc_mcu7t5v0__fillcap_8
XFILLER_55_546 VDD VDD VSS VSS gf180mcu_fd_sc_mcu7t5v0__fill_1
XPHY_EDGE_ROW_118_Right_118 VDD VSS gf180mcu_fd_sc_mcu7t5v0__endcap
XFILLER_82_387 VDD VDD VSS VSS gf180mcu_fd_sc_mcu7t5v0__fillcap_16
XTAP_TAPCELL_ROW_38_777 VDD VSS gf180mcu_fd_sc_mcu7t5v0__filltie
XFILLER_55_579 VDD VDD VSS VSS gf180mcu_fd_sc_mcu7t5v0__fill_1
X_2019_ _2013_/Z _2019_/A2 _2021_/A2 VDD VDD VSS VSS gf180mcu_fd_sc_mcu7t5v0__nor2_1
XFILLER_36_793 VDD VDD VSS VSS gf180mcu_fd_sc_mcu7t5v0__fill_1
XFILLER_51_752 VDD VDD VSS VSS gf180mcu_fd_sc_mcu7t5v0__fillcap_16
XFILLER_11_649 VDD VDD VSS VSS gf180mcu_fd_sc_mcu7t5v0__fillcap_8
XTAP_TAPCELL_ROW_98_1565 VDD VSS gf180mcu_fd_sc_mcu7t5v0__filltie
XTAP_TAPCELL_ROW_98_1554 VDD VSS gf180mcu_fd_sc_mcu7t5v0__filltie
XFILLER_105_754 VDD VDD VSS VSS gf180mcu_fd_sc_mcu7t5v0__fill_1
Xhold193 s_axi_wdata[28] hold193/Z VDD VDD VSS VSS gf180mcu_fd_sc_mcu7t5v0__dlyc_1
XFILLER_77_104 VDD VDD VSS VSS gf180mcu_fd_sc_mcu7t5v0__fill_2
XFILLER_77_137 VDD VDD VSS VSS gf180mcu_fd_sc_mcu7t5v0__fill_2
XFILLER_59_830 VDD VDD VSS VSS gf180mcu_fd_sc_mcu7t5v0__fillcap_8
XFILLER_92_107 VDD VDD VSS VSS gf180mcu_fd_sc_mcu7t5v0__fillcap_32
XFILLER_46_513 VDD VDD VSS VSS gf180mcu_fd_sc_mcu7t5v0__fillcap_8
XFILLER_74_877 VDD VDD VSS VSS gf180mcu_fd_sc_mcu7t5v0__fillcap_32
XTAP_TAPCELL_ROW_107_1683 VDD VSS gf180mcu_fd_sc_mcu7t5v0__filltie
XTAP_TAPCELL_ROW_107_1672 VDD VSS gf180mcu_fd_sc_mcu7t5v0__filltie
XFILLER_14_454 VDD VDD VSS VSS gf180mcu_fd_sc_mcu7t5v0__fill_1
XTAP_TAPCELL_ROW_120_1850 VDD VSS gf180mcu_fd_sc_mcu7t5v0__filltie
XFILLER_6_664 VDD VDD VSS VSS gf180mcu_fd_sc_mcu7t5v0__fill_1
XTAP_TAPCELL_ROW_58_1037 VDD VSS gf180mcu_fd_sc_mcu7t5v0__filltie
XFILLER_45_6 VDD VDD VSS VSS gf180mcu_fd_sc_mcu7t5v0__fill_2
XFILLER_123_562 VDD VDD VSS VSS gf180mcu_fd_sc_mcu7t5v0__fillcap_64
XFILLER_111_702 VDD VDD VSS VSS gf180mcu_fd_sc_mcu7t5v0__fillcap_8
XTAP_TAPCELL_ROW_71_1215 VDD VSS gf180mcu_fd_sc_mcu7t5v0__filltie
XTAP_TAPCELL_ROW_71_1204 VDD VSS gf180mcu_fd_sc_mcu7t5v0__filltie
XTAP_TAPCELL_ROW_131_1990 VDD VSS gf180mcu_fd_sc_mcu7t5v0__filltie
XFILLER_111_746 VDD VDD VSS VSS gf180mcu_fd_sc_mcu7t5v0__fillcap_16
X_4040_ _4040_/D _4148_/RN _4136_/CLK _4040_/Q VDD VDD VSS VSS gf180mcu_fd_sc_mcu7t5v0__dffrnq_1
XFILLER_96_457 VDD VDD VSS VSS gf180mcu_fd_sc_mcu7t5v0__fillcap_16
XFILLER_37_524 VDD VDD VSS VSS gf180mcu_fd_sc_mcu7t5v0__fillcap_8
XFILLER_52_516 VDD VDD VSS VSS gf180mcu_fd_sc_mcu7t5v0__fillcap_8
XTAP_TAPCELL_ROW_69_1177 VDD VSS gf180mcu_fd_sc_mcu7t5v0__filltie
XTAP_TAPCELL_ROW_69_1188 VDD VSS gf180mcu_fd_sc_mcu7t5v0__filltie
XTAP_TAPCELL_ROW_35_736 VDD VSS gf180mcu_fd_sc_mcu7t5v0__filltie
XTAP_TAPCELL_ROW_35_747 VDD VSS gf180mcu_fd_sc_mcu7t5v0__filltie
XFILLER_64_387 VDD VDD VSS VSS gf180mcu_fd_sc_mcu7t5v0__fillcap_16
XTAP_TAPCELL_ROW_82_1355 VDD VSS gf180mcu_fd_sc_mcu7t5v0__filltie
XTAP_TAPCELL_ROW_15_482 VDD VSS gf180mcu_fd_sc_mcu7t5v0__filltie
X_3824_ _3824_/D _3835_/CLK _3824_/Q VDD VDD VSS VSS gf180mcu_fd_sc_mcu7t5v0__dffq_1
XFILLER_20_457 VDD VDD VSS VSS gf180mcu_fd_sc_mcu7t5v0__fillcap_16
X_3755_ _3755_/D _3755_/CLK _3755_/Q VDD VDD VSS VSS gf180mcu_fd_sc_mcu7t5v0__dffq_1
XFILLER_119_857 VDD VDD VSS VSS gf180mcu_fd_sc_mcu7t5v0__fillcap_32
X_3686_ _3686_/D _4072_/CLK _3686_/Q VDD VDD VSS VSS gf180mcu_fd_sc_mcu7t5v0__dffq_1
X_2706_ place85/Z _3810_/Q _2710_/S _3810_/D VDD VDD VSS VSS gf180mcu_fd_sc_mcu7t5v0__mux2_2
XFILLER_106_518 VDD VDD VSS VSS gf180mcu_fd_sc_mcu7t5v0__fillcap_4
XPHY_EDGE_ROW_12_Right_12 VDD VSS gf180mcu_fd_sc_mcu7t5v0__endcap
XTAP_TAPCELL_ROW_93_1495 VDD VSS gf180mcu_fd_sc_mcu7t5v0__filltie
XFILLER_88_925 VDD VDD VSS VSS gf180mcu_fd_sc_mcu7t5v0__fillcap_8
XFILLER_0_818 VDD VDD VSS VSS gf180mcu_fd_sc_mcu7t5v0__fillcap_32
X_2568_ _3753_/Q _4071_/Q _2574_/S _3753_/D VDD VDD VSS VSS gf180mcu_fd_sc_mcu7t5v0__mux2_2
XFILLER_101_212 VDD VDD VSS VSS gf180mcu_fd_sc_mcu7t5v0__fillcap_16
XFILLER_87_413 VDD VDD VSS VSS gf180mcu_fd_sc_mcu7t5v0__fillcap_4
X_2499_ _3722_/Q place80/Z _2503_/S _3722_/D VDD VDD VSS VSS gf180mcu_fd_sc_mcu7t5v0__mux2_2
XFILLER_101_234 VDD VDD VSS VSS gf180mcu_fd_sc_mcu7t5v0__fill_1
XFILLER_74_107 VDD VDD VSS VSS gf180mcu_fd_sc_mcu7t5v0__fillcap_4
XFILLER_74_39 VDD VDD VSS VSS gf180mcu_fd_sc_mcu7t5v0__fill_1
XFILLER_28_535 VDD VDD VSS VSS gf180mcu_fd_sc_mcu7t5v0__fill_2
XFILLER_55_332 VDD VDD VSS VSS gf180mcu_fd_sc_mcu7t5v0__fillcap_16
XPHY_EDGE_ROW_21_Right_21 VDD VSS gf180mcu_fd_sc_mcu7t5v0__endcap
XFILLER_56_877 VDD VDD VSS VSS gf180mcu_fd_sc_mcu7t5v0__fillcap_16
XFILLER_130_34 VDD VDD VSS VSS gf180mcu_fd_sc_mcu7t5v0__fill_1
XFILLER_82_173 VDD VDD VSS VSS gf180mcu_fd_sc_mcu7t5v0__fill_2
XFILLER_43_549 VDD VDD VSS VSS gf180mcu_fd_sc_mcu7t5v0__fillcap_8
XFILLER_90_27 VDD VDD VSS VSS gf180mcu_fd_sc_mcu7t5v0__fillcap_8
XFILLER_51_582 VDD VDD VSS VSS gf180mcu_fd_sc_mcu7t5v0__fill_2
XFILLER_109_345 VDD VDD VSS VSS gf180mcu_fd_sc_mcu7t5v0__fillcap_4
XPHY_EDGE_ROW_30_Right_30 VDD VSS gf180mcu_fd_sc_mcu7t5v0__endcap
XFILLER_99_58 VDD VDD VSS VSS gf180mcu_fd_sc_mcu7t5v0__fillcap_8
XFILLER_105_562 VDD VDD VSS VSS gf180mcu_fd_sc_mcu7t5v0__fillcap_32
XFILLER_3_2 VDD VDD VSS VSS gf180mcu_fd_sc_mcu7t5v0__fillcap_4
XFILLER_2_177 VDD VDD VSS VSS gf180mcu_fd_sc_mcu7t5v0__fillcap_16
XTAP_TAPCELL_ROW_109_1701 VDD VSS gf180mcu_fd_sc_mcu7t5v0__filltie
XFILLER_19_524 VDD VDD VSS VSS gf180mcu_fd_sc_mcu7t5v0__fillcap_8
XFILLER_46_310 VDD VDD VSS VSS gf180mcu_fd_sc_mcu7t5v0__fillcap_4
XPHY_EDGE_ROW_100_Left_233 VDD VSS gf180mcu_fd_sc_mcu7t5v0__endcap
XFILLER_46_387 VDD VDD VSS VSS gf180mcu_fd_sc_mcu7t5v0__fillcap_32
XTAP_TAPCELL_ROW_32_706 VDD VSS gf180mcu_fd_sc_mcu7t5v0__filltie
X_1870_ _3888_/Q _4135_/Q _4134_/Q _1873_/B1 VDD VDD VSS VSS gf180mcu_fd_sc_mcu7t5v0__oai21_1
XFILLER_42_593 VDD VDD VSS VSS gf180mcu_fd_sc_mcu7t5v0__fill_2
XTAP_TAPCELL_ROW_12_441 VDD VSS gf180mcu_fd_sc_mcu7t5v0__filltie
XFILLER_127_142 VDD VDD VSS VSS gf180mcu_fd_sc_mcu7t5v0__fillcap_32
XFILLER_127_120 VDD VDD VSS VSS gf180mcu_fd_sc_mcu7t5v0__fillcap_16
X_3540_ _3540_/A1 _3540_/A2 _4122_/D VDD VDD VSS VSS gf180mcu_fd_sc_mcu7t5v0__xor2_1
X_3471_ _3471_/A1 _4106_/Q _3469_/Z _3471_/B _4106_/D VDD VDD VSS VSS gf180mcu_fd_sc_mcu7t5v0__oai31_2
X_2422_ _3688_/Q place81/Z _2430_/S _3688_/D VDD VDD VSS VSS gf180mcu_fd_sc_mcu7t5v0__mux2_2
XFILLER_124_893 VDD VDD VSS VSS gf180mcu_fd_sc_mcu7t5v0__fill_1
XFILLER_97_722 VDD VDD VSS VSS gf180mcu_fd_sc_mcu7t5v0__fill_2
X_2353_ _3658_/Q place80/Z _2357_/S _3658_/D VDD VDD VSS VSS gf180mcu_fd_sc_mcu7t5v0__mux2_2
XFILLER_36_2 VDD VDD VSS VSS gf180mcu_fd_sc_mcu7t5v0__fillcap_16
XFILLER_69_413 VDD VDD VSS VSS gf180mcu_fd_sc_mcu7t5v0__fillcap_4
XFILLER_111_554 VDD VDD VSS VSS gf180mcu_fd_sc_mcu7t5v0__fillcap_4
XFILLER_96_243 VDD VDD VSS VSS gf180mcu_fd_sc_mcu7t5v0__fill_2
XFILLER_69_446 VDD VDD VSS VSS gf180mcu_fd_sc_mcu7t5v0__fillcap_4
X_2284_ _3629_/Q place82/Z _2298_/S _3629_/D VDD VDD VSS VSS gf180mcu_fd_sc_mcu7t5v0__mux2_2
XFILLER_38_822 VDD VDD VSS VSS gf180mcu_fd_sc_mcu7t5v0__fillcap_32
XFILLER_56_107 VDD VDD VSS VSS gf180mcu_fd_sc_mcu7t5v0__fillcap_64
X_4023_ _4023_/D input92/Z _4023_/CLK _4023_/Q VDD VDD VSS VSS gf180mcu_fd_sc_mcu7t5v0__dffrnq_1
XFILLER_38_877 VDD VDD VSS VSS gf180mcu_fd_sc_mcu7t5v0__fillcap_32
XFILLER_65_696 VDD VDD VSS VSS gf180mcu_fd_sc_mcu7t5v0__fillcap_4
XFILLER_18_590 VDD VDD VSS VSS gf180mcu_fd_sc_mcu7t5v0__fillcap_4
XFILLER_80_699 VDD VDD VSS VSS gf180mcu_fd_sc_mcu7t5v0__fillcap_8
XFILLER_20_210 VDD VDD VSS VSS gf180mcu_fd_sc_mcu7t5v0__fillcap_32
X_3807_ _3807_/D _3864_/CLK _3807_/Q VDD VDD VSS VSS gf180mcu_fd_sc_mcu7t5v0__dffq_1
XFILLER_21_788 VDD VDD VSS VSS gf180mcu_fd_sc_mcu7t5v0__fillcap_8
XFILLER_119_632 VDD VDD VSS VSS gf180mcu_fd_sc_mcu7t5v0__fillcap_32
X_1999_ _4055_/Q _3234_/A1 VDD VDD VSS VSS gf180mcu_fd_sc_mcu7t5v0__clkinv_1
XTAP_TAPCELL_ROW_95_1524 VDD VSS gf180mcu_fd_sc_mcu7t5v0__filltie
X_3738_ _3738_/D _3738_/CLK _3738_/Q VDD VDD VSS VSS gf180mcu_fd_sc_mcu7t5v0__dffq_1
XFILLER_109_68 VDD VDD VSS VSS gf180mcu_fd_sc_mcu7t5v0__fill_2
XFILLER_106_348 VDD VDD VSS VSS gf180mcu_fd_sc_mcu7t5v0__fillcap_32
X_3669_ _3669_/D _3749_/CLK _3669_/Q VDD VDD VSS VSS gf180mcu_fd_sc_mcu7t5v0__dffq_1
XFILLER_102_521 VDD VDD VSS VSS gf180mcu_fd_sc_mcu7t5v0__fillcap_4
XFILLER_102_543 VDD VDD VSS VSS gf180mcu_fd_sc_mcu7t5v0__fillcap_4
XFILLER_87_232 VDD VDD VSS VSS gf180mcu_fd_sc_mcu7t5v0__fillcap_32
XFILLER_0_648 VDD VDD VSS VSS gf180mcu_fd_sc_mcu7t5v0__fillcap_8
XFILLER_130_885 VDD VDD VSS VSS gf180mcu_fd_sc_mcu7t5v0__fill_1
XFILLER_130_874 VDD VDD VSS VSS gf180mcu_fd_sc_mcu7t5v0__fill_1
XFILLER_85_49 VDD VDD VSS VSS gf180mcu_fd_sc_mcu7t5v0__fillcap_16
XFILLER_75_416 VDD VDD VSS VSS gf180mcu_fd_sc_mcu7t5v0__fillcap_4
XFILLER_28_332 VDD VDD VSS VSS gf180mcu_fd_sc_mcu7t5v0__fillcap_16
XFILLER_16_549 VDD VDD VSS VSS gf180mcu_fd_sc_mcu7t5v0__fillcap_8
XFILLER_28_387 VDD VDD VSS VSS gf180mcu_fd_sc_mcu7t5v0__fillcap_8
XTAP_TAPCELL_ROW_104_1642 VDD VSS gf180mcu_fd_sc_mcu7t5v0__filltie
XFILLER_43_368 VDD VDD VSS VSS gf180mcu_fd_sc_mcu7t5v0__fillcap_4
XFILLER_12_733 VDD VDD VSS VSS gf180mcu_fd_sc_mcu7t5v0__fill_2
XFILLER_8_737 VDD VDD VSS VSS gf180mcu_fd_sc_mcu7t5v0__fillcap_64
XFILLER_11_276 VDD VDD VSS VSS gf180mcu_fd_sc_mcu7t5v0__fillcap_4
XFILLER_109_142 VDD VDD VSS VSS gf180mcu_fd_sc_mcu7t5v0__fillcap_4
XTAP_TAPCELL_ROW_55_1007 VDD VSS gf180mcu_fd_sc_mcu7t5v0__filltie
XTAP_TAPCELL_ROW_115_1782 VDD VSS gf180mcu_fd_sc_mcu7t5v0__filltie
XFILLER_79_722 VDD VDD VSS VSS gf180mcu_fd_sc_mcu7t5v0__fill_1
XFILLER_78_243 VDD VDD VSS VSS gf180mcu_fd_sc_mcu7t5v0__fill_2
XFILLER_78_221 VDD VDD VSS VSS gf180mcu_fd_sc_mcu7t5v0__fill_2
XFILLER_59_72 VDD VDD VSS VSS gf180mcu_fd_sc_mcu7t5v0__fillcap_16
XFILLER_67_906 VDD VDD VSS VSS gf180mcu_fd_sc_mcu7t5v0__fillcap_4
XFILLER_121_874 VDD VDD VSS VSS gf180mcu_fd_sc_mcu7t5v0__fillcap_16
XFILLER_93_202 VDD VDD VSS VSS gf180mcu_fd_sc_mcu7t5v0__fillcap_8
XFILLER_67_928 VDD VDD VSS VSS gf180mcu_fd_sc_mcu7t5v0__fillcap_4
XFILLER_94_769 VDD VDD VSS VSS gf180mcu_fd_sc_mcu7t5v0__fillcap_4
XTAP_TAPCELL_ROW_17_511 VDD VSS gf180mcu_fd_sc_mcu7t5v0__filltie
XFILLER_34_313 VDD VDD VSS VSS gf180mcu_fd_sc_mcu7t5v0__fill_2
XFILLER_35_858 VDD VDD VSS VSS gf180mcu_fd_sc_mcu7t5v0__fillcap_8
XFILLER_46_173 VDD VDD VSS VSS gf180mcu_fd_sc_mcu7t5v0__fill_2
XFILLER_47_696 VDD VDD VSS VSS gf180mcu_fd_sc_mcu7t5v0__fillcap_4
XTAP_TAPCELL_ROW_66_1147 VDD VSS gf180mcu_fd_sc_mcu7t5v0__filltie
XFILLER_22_519 VDD VDD VSS VSS gf180mcu_fd_sc_mcu7t5v0__fillcap_4
XTAP_TAPCELL_ROW_45_875 VDD VSS gf180mcu_fd_sc_mcu7t5v0__filltie
XFILLER_62_699 VDD VDD VSS VSS gf180mcu_fd_sc_mcu7t5v0__fillcap_32
X_1922_ _4142_/Q _1923_/B VDD VDD VSS VSS gf180mcu_fd_sc_mcu7t5v0__clkinv_1
X_1853_ _1913_/A1 _1935_/A4 _1853_/B _1855_/A2 VDD VDD VSS VSS gf180mcu_fd_sc_mcu7t5v0__aoi21_1
X_3523_ place76/Z _3500_/I _4116_/D VDD VDD VSS VSS gf180mcu_fd_sc_mcu7t5v0__xor2_1
XTAP_TAPCELL_ROW_77_1287 VDD VSS gf180mcu_fd_sc_mcu7t5v0__filltie
X_3454_ _4104_/Q _3495_/B _3453_/Z _4103_/D VDD VDD VSS VSS gf180mcu_fd_sc_mcu7t5v0__nor3_2
XFILLER_131_627 VDD VDD VSS VSS gf180mcu_fd_sc_mcu7t5v0__fill_2
X_3385_ _1986_/C _3385_/A2 _3389_/A1 _3391_/A1 VDD VDD VSS VSS gf180mcu_fd_sc_mcu7t5v0__nand3_1
XTAP_TAPCELL_ROW_90_1454 VDD VSS gf180mcu_fd_sc_mcu7t5v0__filltie
XFILLER_97_585 VDD VDD VSS VSS gf180mcu_fd_sc_mcu7t5v0__fillcap_8
X_2336_ _4073_/Q _3651_/Q _2338_/S _3651_/D VDD VDD VSS VSS gf180mcu_fd_sc_mcu7t5v0__mux2_2
XFILLER_69_276 VDD VDD VSS VSS gf180mcu_fd_sc_mcu7t5v0__fillcap_4
X_2267_ _2267_/I _2267_/ZN VDD VDD VSS VSS gf180mcu_fd_sc_mcu7t5v0__inv_1
XFILLER_85_769 VDD VDD VSS VSS gf180mcu_fd_sc_mcu7t5v0__fill_1
Xclkbuf_leaf_49_clk clkload0/I _4112_/CLK VDD VDD VSS VSS gf180mcu_fd_sc_mcu7t5v0__clkbuf_8
X_4006_ _4006_/D input92/Z _4045_/CLK _4006_/Q VDD VDD VSS VSS gf180mcu_fd_sc_mcu7t5v0__dffrnq_1
XFILLER_65_460 VDD VDD VSS VSS gf180mcu_fd_sc_mcu7t5v0__fillcap_16
X_2198_ _2198_/A1 _2198_/A2 _2198_/ZN VDD VDD VSS VSS gf180mcu_fd_sc_mcu7t5v0__nand2_1
XFILLER_52_132 VDD VDD VSS VSS gf180mcu_fd_sc_mcu7t5v0__fillcap_8
XFILLER_122_649 VDD VDD VSS VSS gf180mcu_fd_sc_mcu7t5v0__fill_2
XFILLER_96_37 VDD VDD VSS VSS gf180mcu_fd_sc_mcu7t5v0__fillcap_8
XFILLER_102_373 VDD VDD VSS VSS gf180mcu_fd_sc_mcu7t5v0__fillcap_8
XFILLER_49_928 VDD VDD VSS VSS gf180mcu_fd_sc_mcu7t5v0__fillcap_4
XFILLER_75_246 VDD VDD VSS VSS gf180mcu_fd_sc_mcu7t5v0__fillcap_32
XFILLER_84_780 VDD VDD VSS VSS gf180mcu_fd_sc_mcu7t5v0__fill_1
XFILLER_44_699 VDD VDD VSS VSS gf180mcu_fd_sc_mcu7t5v0__fillcap_32
XFILLER_31_349 VDD VDD VSS VSS gf180mcu_fd_sc_mcu7t5v0__fill_1
XTAP_TAPCELL_ROW_42_834 VDD VSS gf180mcu_fd_sc_mcu7t5v0__filltie
XFILLER_12_563 VDD VDD VSS VSS gf180mcu_fd_sc_mcu7t5v0__fill_2
XFILLER_40_894 VDD VDD VSS VSS gf180mcu_fd_sc_mcu7t5v0__fill_1
XTAP_TAPCELL_ROW_61_1077 VDD VSS gf180mcu_fd_sc_mcu7t5v0__filltie
XTAP_TAPCELL_ROW_117_1811 VDD VSS gf180mcu_fd_sc_mcu7t5v0__filltie
XFILLER_126_933 VDD VDD VSS VSS gf180mcu_fd_sc_mcu7t5v0__fill_1
XFILLER_125_454 VDD VDD VSS VSS gf180mcu_fd_sc_mcu7t5v0__fillcap_16
XFILLER_112_104 VDD VDD VSS VSS gf180mcu_fd_sc_mcu7t5v0__fill_1
XFILLER_98_349 VDD VDD VSS VSS gf180mcu_fd_sc_mcu7t5v0__fill_2
XFILLER_94_511 VDD VDD VSS VSS gf180mcu_fd_sc_mcu7t5v0__fillcap_8
XFILLER_39_416 VDD VDD VSS VSS gf180mcu_fd_sc_mcu7t5v0__fillcap_4
X_2121_ _2152_/S _2134_/A1 _2219_/B VDD VDD VSS VSS gf180mcu_fd_sc_mcu7t5v0__nand2_1
XFILLER_13_4 VDD VDD VSS VSS gf180mcu_fd_sc_mcu7t5v0__fill_1
XTAP_TAPCELL_ROW_128_1951 VDD VSS gf180mcu_fd_sc_mcu7t5v0__filltie
X_2052_ _1855_/B _2052_/A2 _2052_/Z VDD VDD VSS VSS gf180mcu_fd_sc_mcu7t5v0__xor2_1
XFILLER_47_471 VDD VDD VSS VSS gf180mcu_fd_sc_mcu7t5v0__fillcap_8
XFILLER_34_143 VDD VDD VSS VSS gf180mcu_fd_sc_mcu7t5v0__fill_2
X_2954_ _4043_/Q _3923_/Q _2972_/S _3923_/D VDD VDD VSS VSS gf180mcu_fd_sc_mcu7t5v0__mux2_2
X_1905_ _3893_/Q _3894_/Q _1905_/Z VDD VDD VSS VSS gf180mcu_fd_sc_mcu7t5v0__or2_1
X_2885_ _1892_/C _2900_/S _2885_/B _3890_/D VDD VDD VSS VSS gf180mcu_fd_sc_mcu7t5v0__oai21_1
XTAP_TAPCELL_ROW_79_1316 VDD VSS gf180mcu_fd_sc_mcu7t5v0__filltie
X_1836_ _2899_/A1 _1940_/B _1836_/Z VDD VDD VSS VSS gf180mcu_fd_sc_mcu7t5v0__and2_2
XPHY_EDGE_ROW_6_Right_6 VDD VSS gf180mcu_fd_sc_mcu7t5v0__endcap
XFILLER_117_933 VDD VDD VSS VSS gf180mcu_fd_sc_mcu7t5v0__fill_1
X_3506_ _4110_/Q _4111_/Q _3506_/Z VDD VDD VSS VSS gf180mcu_fd_sc_mcu7t5v0__or2_1
XFILLER_104_638 VDD VDD VSS VSS gf180mcu_fd_sc_mcu7t5v0__fillcap_16
XFILLER_89_349 VDD VDD VSS VSS gf180mcu_fd_sc_mcu7t5v0__fill_1
X_3437_ _3444_/A1 _3437_/A2 _3441_/A2 VDD VDD VSS VSS gf180mcu_fd_sc_mcu7t5v0__nor2_1
XFILLER_112_660 VDD VDD VSS VSS gf180mcu_fd_sc_mcu7t5v0__fillcap_4
XFILLER_106_47 VDD VDD VSS VSS gf180mcu_fd_sc_mcu7t5v0__fill_2
XFILLER_100_811 VDD VDD VSS VSS gf180mcu_fd_sc_mcu7t5v0__fill_2
XFILLER_100_800 VDD VDD VSS VSS gf180mcu_fd_sc_mcu7t5v0__fillcap_4
X_3368_ _3316_/Z _3368_/A2 _3368_/B _4083_/D VDD VDD VSS VSS gf180mcu_fd_sc_mcu7t5v0__oai21_1
X_2319_ _3644_/Q _4074_/Q _2319_/S _3644_/D VDD VDD VSS VSS gf180mcu_fd_sc_mcu7t5v0__mux2_2
XFILLER_100_877 VDD VDD VSS VSS gf180mcu_fd_sc_mcu7t5v0__fillcap_8
X_3299_ _4068_/Q _4162_/Q _4157_/D _4068_/D VDD VDD VSS VSS gf180mcu_fd_sc_mcu7t5v0__mux2_2
XFILLER_72_205 VDD VDD VSS VSS gf180mcu_fd_sc_mcu7t5v0__fill_2
XFILLER_81_772 VDD VDD VSS VSS gf180mcu_fd_sc_mcu7t5v0__fillcap_8
XFILLER_14_817 VDD VDD VSS VSS gf180mcu_fd_sc_mcu7t5v0__fill_1
XTAP_TAPCELL_ROW_0_275 VDD VSS gf180mcu_fd_sc_mcu7t5v0__filltie
XTAP_TAPCELL_ROW_0_286 VDD VSS gf180mcu_fd_sc_mcu7t5v0__filltie
XTAP_TAPCELL_ROW_101_1601 VDD VSS gf180mcu_fd_sc_mcu7t5v0__filltie
XFILLER_15_66 VDD VDD VSS VSS gf180mcu_fd_sc_mcu7t5v0__fillcap_4
XFILLER_40_168 VDD VDD VSS VSS gf180mcu_fd_sc_mcu7t5v0__fillcap_4
XFILLER_108_933 VDD VDD VSS VSS gf180mcu_fd_sc_mcu7t5v0__fill_1
XFILLER_5_559 VDD VDD VSS VSS gf180mcu_fd_sc_mcu7t5v0__fill_1
XFILLER_122_457 VDD VDD VSS VSS gf180mcu_fd_sc_mcu7t5v0__fillcap_64
XTAP_TAPCELL_ROW_112_1741 VDD VSS gf180mcu_fd_sc_mcu7t5v0__filltie
Xinput110 hold219/Z _3117_/I1 VDD VDD VSS VSS gf180mcu_fd_sc_mcu7t5v0__dlyb_1
XTAP_TAPCELL_ROW_8_386 VDD VSS gf180mcu_fd_sc_mcu7t5v0__filltie
Xinput132 hold224/Z _3158_/I1 VDD VDD VSS VSS gf180mcu_fd_sc_mcu7t5v0__dlyb_1
Xinput121 hold200/Z _3138_/I1 VDD VDD VSS VSS gf180mcu_fd_sc_mcu7t5v0__dlyb_1
XFILLER_37_909 VDD VDD VSS VSS gf180mcu_fd_sc_mcu7t5v0__fill_1
XFILLER_91_536 VDD VDD VSS VSS gf180mcu_fd_sc_mcu7t5v0__fillcap_16
XFILLER_63_205 VDD VDD VSS VSS gf180mcu_fd_sc_mcu7t5v0__fillcap_4
XTAP_TAPCELL_ROW_63_1106 VDD VSS gf180mcu_fd_sc_mcu7t5v0__filltie
XTAP_TAPCELL_ROW_123_1881 VDD VSS gf180mcu_fd_sc_mcu7t5v0__filltie
XFILLER_71_282 VDD VDD VSS VSS gf180mcu_fd_sc_mcu7t5v0__fillcap_32
XFILLER_9_832 VDD VDD VSS VSS gf180mcu_fd_sc_mcu7t5v0__fillcap_8
XPHY_EDGE_ROW_59_Right_59 VDD VSS gf180mcu_fd_sc_mcu7t5v0__endcap
X_2670_ place86/Z _3793_/Q _2676_/S _3793_/D VDD VDD VSS VSS gf180mcu_fd_sc_mcu7t5v0__mux2_2
XFILLER_114_925 VDD VDD VSS VSS gf180mcu_fd_sc_mcu7t5v0__fillcap_8
XTAP_TAPCELL_ROW_74_1246 VDD VSS gf180mcu_fd_sc_mcu7t5v0__filltie
XFILLER_99_647 VDD VDD VSS VSS gf180mcu_fd_sc_mcu7t5v0__fillcap_8
XFILLER_100_107 VDD VDD VSS VSS gf180mcu_fd_sc_mcu7t5v0__fillcap_32
XFILLER_95_842 VDD VDD VSS VSS gf180mcu_fd_sc_mcu7t5v0__fillcap_16
XPHY_EDGE_ROW_68_Right_68 VDD VSS gf180mcu_fd_sc_mcu7t5v0__endcap
X_2104_ _3741_/Q _3749_/Q _3637_/Q _3645_/Q place79/Z place78/Z _2104_/Z VDD VDD VSS
+ VSS gf180mcu_fd_sc_mcu7t5v0__mux4_1
XFILLER_28_909 VDD VDD VSS VSS gf180mcu_fd_sc_mcu7t5v0__fillcap_16
XFILLER_39_268 VDD VDD VSS VSS gf180mcu_fd_sc_mcu7t5v0__fill_2
XFILLER_67_577 VDD VDD VSS VSS gf180mcu_fd_sc_mcu7t5v0__fillcap_16
X_3084_ _3983_/Q _3084_/I1 _4131_/D _3983_/D VDD VDD VSS VSS gf180mcu_fd_sc_mcu7t5v0__mux2_2
XFILLER_27_419 VDD VDD VSS VSS gf180mcu_fd_sc_mcu7t5v0__fill_1
XFILLER_36_931 VDD VDD VSS VSS gf180mcu_fd_sc_mcu7t5v0__fill_2
X_2035_ _4135_/Q _4134_/Q _4133_/Q _4132_/Q _2079_/A2 VDD VDD VSS VSS gf180mcu_fd_sc_mcu7t5v0__nand4_1
XTAP_TAPCELL_ROW_25_609 VDD VSS gf180mcu_fd_sc_mcu7t5v0__filltie
XFILLER_51_912 VDD VDD VSS VSS gf180mcu_fd_sc_mcu7t5v0__fillcap_16
XFILLER_63_772 VDD VDD VSS VSS gf180mcu_fd_sc_mcu7t5v0__fillcap_64
XTAP_TAPCELL_ROW_85_1397 VDD VSS gf180mcu_fd_sc_mcu7t5v0__filltie
XTAP_TAPCELL_ROW_85_1386 VDD VSS gf180mcu_fd_sc_mcu7t5v0__filltie
XFILLER_50_422 VDD VDD VSS VSS gf180mcu_fd_sc_mcu7t5v0__fill_1
XFILLER_62_271 VDD VDD VSS VSS gf180mcu_fd_sc_mcu7t5v0__fillcap_4
XPHY_EDGE_ROW_77_Right_77 VDD VSS gf180mcu_fd_sc_mcu7t5v0__endcap
X_3986_ _3986_/D input92/Z clkload9/I _3986_/Q VDD VDD VSS VSS gf180mcu_fd_sc_mcu7t5v0__dffrnq_1
X_2937_ _4035_/Q _3915_/Q _2972_/S _3915_/D VDD VDD VSS VSS gf180mcu_fd_sc_mcu7t5v0__mux2_2
XFILLER_108_229 VDD VDD VSS VSS gf180mcu_fd_sc_mcu7t5v0__fillcap_4
X_1819_ _3895_/Q _3896_/Q _3893_/Q _3894_/Q _1819_/Z VDD VDD VSS VSS gf180mcu_fd_sc_mcu7t5v0__or4_2
X_2799_ place83/Z _3852_/Q _2799_/S _3852_/D VDD VDD VSS VSS gf180mcu_fd_sc_mcu7t5v0__mux2_2
XFILLER_132_711 VDD VDD VSS VSS gf180mcu_fd_sc_mcu7t5v0__fill_2
XFILLER_104_435 VDD VDD VSS VSS gf180mcu_fd_sc_mcu7t5v0__fill_1
XFILLER_104_457 VDD VDD VSS VSS gf180mcu_fd_sc_mcu7t5v0__fillcap_8
XPHY_EDGE_ROW_86_Right_86 VDD VSS gf180mcu_fd_sc_mcu7t5v0__endcap
XFILLER_131_276 VDD VDD VSS VSS gf180mcu_fd_sc_mcu7t5v0__fillcap_4
XFILLER_98_680 VDD VDD VSS VSS gf180mcu_fd_sc_mcu7t5v0__fillcap_8
XTAP_TAPCELL_ROW_5_345 VDD VSS gf180mcu_fd_sc_mcu7t5v0__filltie
XFILLER_58_533 VDD VDD VSS VSS gf180mcu_fd_sc_mcu7t5v0__fill_1
XFILLER_100_663 VDD VDD VSS VSS gf180mcu_fd_sc_mcu7t5v0__fill_2
XFILLER_85_352 VDD VDD VSS VSS gf180mcu_fd_sc_mcu7t5v0__fillcap_16
XTAP_TAPCELL_ROW_5_356 VDD VSS gf180mcu_fd_sc_mcu7t5v0__filltie
XFILLER_54_761 VDD VDD VSS VSS gf180mcu_fd_sc_mcu7t5v0__fill_1
XPHY_EDGE_ROW_95_Right_95 VDD VSS gf180mcu_fd_sc_mcu7t5v0__endcap
XFILLER_41_422 VDD VDD VSS VSS gf180mcu_fd_sc_mcu7t5v0__fillcap_64
XFILLER_53_282 VDD VDD VSS VSS gf180mcu_fd_sc_mcu7t5v0__fillcap_32
XFILLER_13_157 VDD VDD VSS VSS gf180mcu_fd_sc_mcu7t5v0__fillcap_8
XFILLER_13_135 VDD VDD VSS VSS gf180mcu_fd_sc_mcu7t5v0__fillcap_4
XTAP_TAPCELL_ROW_52_962 VDD VSS gf180mcu_fd_sc_mcu7t5v0__filltie
XFILLER_42_53 VDD VDD VSS VSS gf180mcu_fd_sc_mcu7t5v0__fillcap_8
XFILLER_127_516 VDD VDD VSS VSS gf180mcu_fd_sc_mcu7t5v0__fill_2
XFILLER_10_831 VDD VDD VSS VSS gf180mcu_fd_sc_mcu7t5v0__fill_2
XFILLER_6_802 VDD VDD VSS VSS gf180mcu_fd_sc_mcu7t5v0__fill_2
XFILLER_111_928 VDD VDD VSS VSS gf180mcu_fd_sc_mcu7t5v0__fillcap_4
XFILLER_111_906 VDD VDD VSS VSS gf180mcu_fd_sc_mcu7t5v0__fillcap_4
XFILLER_1_562 VDD VDD VSS VSS gf180mcu_fd_sc_mcu7t5v0__fill_1
XFILLER_67_72 VDD VDD VSS VSS gf180mcu_fd_sc_mcu7t5v0__fillcap_16
XFILLER_77_886 VDD VDD VSS VSS gf180mcu_fd_sc_mcu7t5v0__fillcap_8
XTAP_TAPCELL_ROW_125_1910 VDD VSS gf180mcu_fd_sc_mcu7t5v0__filltie
XFILLER_36_227 VDD VDD VSS VSS gf180mcu_fd_sc_mcu7t5v0__fillcap_16
XFILLER_33_912 VDD VDD VSS VSS gf180mcu_fd_sc_mcu7t5v0__fillcap_16
XFILLER_45_772 VDD VDD VSS VSS gf180mcu_fd_sc_mcu7t5v0__fillcap_8
XFILLER_44_271 VDD VDD VSS VSS gf180mcu_fd_sc_mcu7t5v0__fill_1
X_3840_ _3840_/D _3864_/CLK _3840_/Q VDD VDD VSS VSS gf180mcu_fd_sc_mcu7t5v0__dffq_1
XFILLER_60_775 VDD VDD VSS VSS gf180mcu_fd_sc_mcu7t5v0__fillcap_16
XFILLER_13_680 VDD VDD VSS VSS gf180mcu_fd_sc_mcu7t5v0__fillcap_8
X_3771_ _3771_/D clkload9/I _3771_/Q VDD VDD VSS VSS gf180mcu_fd_sc_mcu7t5v0__dffq_1
X_2722_ _3817_/Q place86/Z _2728_/S _3817_/D VDD VDD VSS VSS gf180mcu_fd_sc_mcu7t5v0__mux2_2
XFILLER_118_527 VDD VDD VSS VSS gf180mcu_fd_sc_mcu7t5v0__fillcap_8
XFILLER_9_695 VDD VDD VSS VSS gf180mcu_fd_sc_mcu7t5v0__fillcap_4
XTAP_TAPCELL_ROW_30_678 VDD VSS gf180mcu_fd_sc_mcu7t5v0__filltie
X_2584_ _3757_/Q place90/Z _2598_/S _3757_/D VDD VDD VSS VSS gf180mcu_fd_sc_mcu7t5v0__mux2_2
XFILLER_99_422 VDD VDD VSS VSS gf180mcu_fd_sc_mcu7t5v0__fillcap_32
XFILLER_113_254 VDD VDD VSS VSS gf180mcu_fd_sc_mcu7t5v0__fillcap_8
XFILLER_99_488 VDD VDD VSS VSS gf180mcu_fd_sc_mcu7t5v0__fill_2
XFILLER_101_438 VDD VDD VSS VSS gf180mcu_fd_sc_mcu7t5v0__fillcap_32
XFILLER_101_416 VDD VDD VSS VSS gf180mcu_fd_sc_mcu7t5v0__fillcap_4
XFILLER_67_352 VDD VDD VSS VSS gf180mcu_fd_sc_mcu7t5v0__fillcap_32
X_3136_ _4008_/Q _3136_/I1 _3160_/S _4008_/D VDD VDD VSS VSS gf180mcu_fd_sc_mcu7t5v0__mux2_2
XTAP_TAPCELL_ROW_87_1415 VDD VSS gf180mcu_fd_sc_mcu7t5v0__filltie
XFILLER_82_311 VDD VDD VSS VSS gf180mcu_fd_sc_mcu7t5v0__fillcap_4
XTAP_TAPCELL_ROW_2_315 VDD VSS gf180mcu_fd_sc_mcu7t5v0__filltie
XFILLER_27_205 VDD VDD VSS VSS gf180mcu_fd_sc_mcu7t5v0__fillcap_4
X_3067_ _4037_/Q _3974_/Q _3081_/S _3974_/D VDD VDD VSS VSS gf180mcu_fd_sc_mcu7t5v0__mux2_2
XFILLER_94_182 VDD VDD VSS VSS gf180mcu_fd_sc_mcu7t5v0__fillcap_16
XFILLER_82_333 VDD VDD VSS VSS gf180mcu_fd_sc_mcu7t5v0__fillcap_8
XFILLER_55_558 VDD VDD VSS VSS gf180mcu_fd_sc_mcu7t5v0__fill_2
X_2018_ _4133_/Q _4132_/Q _2019_/A2 VDD VDD VSS VSS gf180mcu_fd_sc_mcu7t5v0__xnor2_1
XFILLER_82_366 VDD VDD VSS VSS gf180mcu_fd_sc_mcu7t5v0__fillcap_16
XFILLER_82_355 VDD VDD VSS VSS gf180mcu_fd_sc_mcu7t5v0__fill_2
XTAP_TAPCELL_ROW_38_778 VDD VSS gf180mcu_fd_sc_mcu7t5v0__filltie
XFILLER_23_422 VDD VDD VSS VSS gf180mcu_fd_sc_mcu7t5v0__fillcap_8
XFILLER_35_282 VDD VDD VSS VSS gf180mcu_fd_sc_mcu7t5v0__fillcap_32
XFILLER_50_241 VDD VDD VSS VSS gf180mcu_fd_sc_mcu7t5v0__fillcap_4
XFILLER_11_628 VDD VDD VSS VSS gf180mcu_fd_sc_mcu7t5v0__fill_2
XFILLER_23_488 VDD VDD VSS VSS gf180mcu_fd_sc_mcu7t5v0__fill_2
X_3969_ _3969_/D _2279_/I _4125_/CLK _3969_/Q VDD VDD VSS VSS gf180mcu_fd_sc_mcu7t5v0__dffrnq_1
XFILLER_109_538 VDD VDD VSS VSS gf180mcu_fd_sc_mcu7t5v0__fillcap_16
XTAP_TAPCELL_ROW_98_1555 VDD VSS gf180mcu_fd_sc_mcu7t5v0__filltie
XFILLER_12_34 VDD VDD VSS VSS gf180mcu_fd_sc_mcu7t5v0__fill_1
XTAP_TAPCELL_ROW_98_1566 VDD VSS gf180mcu_fd_sc_mcu7t5v0__filltie
XFILLER_88_27 VDD VDD VSS VSS gf180mcu_fd_sc_mcu7t5v0__fillcap_8
XFILLER_3_838 VDD VDD VSS VSS gf180mcu_fd_sc_mcu7t5v0__fill_2
XFILLER_105_744 VDD VDD VSS VSS gf180mcu_fd_sc_mcu7t5v0__fillcap_8
XFILLER_105_788 VDD VDD VSS VSS gf180mcu_fd_sc_mcu7t5v0__fillcap_4
XFILLER_104_243 VDD VDD VSS VSS gf180mcu_fd_sc_mcu7t5v0__fill_2
Xhold194 s_axi_awaddr[5] hold194/Z VDD VDD VSS VSS gf180mcu_fd_sc_mcu7t5v0__dlyc_1
XFILLER_74_801 VDD VDD VSS VSS gf180mcu_fd_sc_mcu7t5v0__fillcap_4
XFILLER_59_842 VDD VDD VSS VSS gf180mcu_fd_sc_mcu7t5v0__fillcap_16
XFILLER_58_363 VDD VDD VSS VSS gf180mcu_fd_sc_mcu7t5v0__fillcap_16
XFILLER_15_912 VDD VDD VSS VSS gf180mcu_fd_sc_mcu7t5v0__fillcap_16
XFILLER_27_772 VDD VDD VSS VSS gf180mcu_fd_sc_mcu7t5v0__fillcap_64
XTAP_TAPCELL_ROW_107_1673 VDD VSS gf180mcu_fd_sc_mcu7t5v0__filltie
XTAP_TAPCELL_ROW_120_1851 VDD VSS gf180mcu_fd_sc_mcu7t5v0__filltie
XTAP_TAPCELL_ROW_120_1840 VDD VSS gf180mcu_fd_sc_mcu7t5v0__filltie
XFILLER_128_803 VDD VDD VSS VSS gf180mcu_fd_sc_mcu7t5v0__fill_2
XFILLER_127_368 VDD VDD VSS VSS gf180mcu_fd_sc_mcu7t5v0__fillcap_4
XFILLER_6_687 VDD VDD VSS VSS gf180mcu_fd_sc_mcu7t5v0__fill_2
XFILLER_5_142 VDD VDD VSS VSS gf180mcu_fd_sc_mcu7t5v0__fillcap_8
XTAP_TAPCELL_ROW_58_1038 VDD VSS gf180mcu_fd_sc_mcu7t5v0__filltie
XTAP_TAPCELL_ROW_71_1205 VDD VSS gf180mcu_fd_sc_mcu7t5v0__filltie
XTAP_TAPCELL_ROW_131_1991 VDD VSS gf180mcu_fd_sc_mcu7t5v0__filltie
XFILLER_110_213 VDD VDD VSS VSS gf180mcu_fd_sc_mcu7t5v0__fill_1
XFILLER_2_871 VDD VDD VSS VSS gf180mcu_fd_sc_mcu7t5v0__fillcap_4
XFILLER_68_127 VDD VDD VSS VSS gf180mcu_fd_sc_mcu7t5v0__fill_1
XFILLER_110_235 VDD VDD VSS VSS gf180mcu_fd_sc_mcu7t5v0__fillcap_8
XFILLER_77_683 VDD VDD VSS VSS gf180mcu_fd_sc_mcu7t5v0__fillcap_16
XFILLER_49_352 VDD VDD VSS VSS gf180mcu_fd_sc_mcu7t5v0__fillcap_64
XFILLER_76_171 VDD VDD VSS VSS gf180mcu_fd_sc_mcu7t5v0__fillcap_4
XFILLER_37_536 VDD VDD VSS VSS gf180mcu_fd_sc_mcu7t5v0__fill_2
XFILLER_37_558 VDD VDD VSS VSS gf180mcu_fd_sc_mcu7t5v0__fill_2
XFILLER_64_311 VDD VDD VSS VSS gf180mcu_fd_sc_mcu7t5v0__fillcap_4
XTAP_TAPCELL_ROW_69_1178 VDD VSS gf180mcu_fd_sc_mcu7t5v0__filltie
XFILLER_91_174 VDD VDD VSS VSS gf180mcu_fd_sc_mcu7t5v0__fill_2
XFILLER_17_282 VDD VDD VSS VSS gf180mcu_fd_sc_mcu7t5v0__fillcap_64
XTAP_TAPCELL_ROW_35_737 VDD VSS gf180mcu_fd_sc_mcu7t5v0__filltie
XTAP_TAPCELL_ROW_69_1189 VDD VSS gf180mcu_fd_sc_mcu7t5v0__filltie
XTAP_TAPCELL_ROW_82_1356 VDD VSS gf180mcu_fd_sc_mcu7t5v0__filltie
XFILLER_32_241 VDD VDD VSS VSS gf180mcu_fd_sc_mcu7t5v0__fillcap_4
X_3823_ _3823_/D _3835_/CLK _3823_/Q VDD VDD VSS VSS gf180mcu_fd_sc_mcu7t5v0__dffq_1
XFILLER_32_263 VDD VDD VSS VSS gf180mcu_fd_sc_mcu7t5v0__fill_1
XTAP_TAPCELL_ROW_15_483 VDD VSS gf180mcu_fd_sc_mcu7t5v0__filltie
XFILLER_20_425 VDD VDD VSS VSS gf180mcu_fd_sc_mcu7t5v0__fill_1
XFILLER_32_296 VDD VDD VSS VSS gf180mcu_fd_sc_mcu7t5v0__fillcap_16
XFILLER_60_594 VDD VDD VSS VSS gf180mcu_fd_sc_mcu7t5v0__fill_1
XFILLER_119_836 VDD VDD VSS VSS gf180mcu_fd_sc_mcu7t5v0__fillcap_4
XFILLER_118_313 VDD VDD VSS VSS gf180mcu_fd_sc_mcu7t5v0__fill_2
X_3754_ _3754_/D _4094_/CLK _3754_/Q VDD VDD VSS VSS gf180mcu_fd_sc_mcu7t5v0__dffq_1
X_3685_ _3685_/D _3968_/CLK _3685_/Q VDD VDD VSS VSS gf180mcu_fd_sc_mcu7t5v0__dffq_1
XFILLER_9_492 VDD VDD VSS VSS gf180mcu_fd_sc_mcu7t5v0__fillcap_32
X_2636_ place84/Z _3779_/Q _2638_/S _3779_/D VDD VDD VSS VSS gf180mcu_fd_sc_mcu7t5v0__mux2_2
XTAP_TAPCELL_ROW_93_1496 VDD VSS gf180mcu_fd_sc_mcu7t5v0__filltie
XFILLER_87_436 VDD VDD VSS VSS gf180mcu_fd_sc_mcu7t5v0__fill_1
XFILLER_59_138 VDD VDD VSS VSS gf180mcu_fd_sc_mcu7t5v0__fill_2
XFILLER_114_47 VDD VDD VSS VSS gf180mcu_fd_sc_mcu7t5v0__fill_1
XFILLER_101_279 VDD VDD VSS VSS gf180mcu_fd_sc_mcu7t5v0__fill_1
XFILLER_28_558 VDD VDD VSS VSS gf180mcu_fd_sc_mcu7t5v0__fill_1
X_3119_ _4000_/Q _3119_/I1 _3160_/S _4000_/D VDD VDD VSS VSS gf180mcu_fd_sc_mcu7t5v0__mux2_2
XFILLER_71_804 VDD VDD VSS VSS gf180mcu_fd_sc_mcu7t5v0__fillcap_8
X_4099_ _4099_/D _2279_/I _4112_/CLK _4099_/Q VDD VDD VSS VSS gf180mcu_fd_sc_mcu7t5v0__dffrnq_1
XFILLER_83_697 VDD VDD VSS VSS gf180mcu_fd_sc_mcu7t5v0__fill_2
XFILLER_71_837 VDD VDD VSS VSS gf180mcu_fd_sc_mcu7t5v0__fill_2
XFILLER_24_731 VDD VDD VSS VSS gf180mcu_fd_sc_mcu7t5v0__fillcap_4
XFILLER_70_325 VDD VDD VSS VSS gf180mcu_fd_sc_mcu7t5v0__fill_1
XFILLER_23_88 VDD VDD VSS VSS gf180mcu_fd_sc_mcu7t5v0__fillcap_8
XFILLER_23_66 VDD VDD VSS VSS gf180mcu_fd_sc_mcu7t5v0__fillcap_4
XFILLER_125_839 VDD VDD VSS VSS gf180mcu_fd_sc_mcu7t5v0__fill_1
XFILLER_109_368 VDD VDD VSS VSS gf180mcu_fd_sc_mcu7t5v0__fillcap_8
XFILLER_124_349 VDD VDD VSS VSS gf180mcu_fd_sc_mcu7t5v0__fillcap_16
XFILLER_2_101 VDD VDD VSS VSS gf180mcu_fd_sc_mcu7t5v0__fillcap_4
XTAP_TAPCELL_ROW_109_1702 VDD VSS gf180mcu_fd_sc_mcu7t5v0__filltie
XFILLER_58_193 VDD VDD VSS VSS gf180mcu_fd_sc_mcu7t5v0__fillcap_8
XFILLER_74_675 VDD VDD VSS VSS gf180mcu_fd_sc_mcu7t5v0__fill_2
XFILLER_74_653 VDD VDD VSS VSS gf180mcu_fd_sc_mcu7t5v0__fillcap_8
XFILLER_34_539 VDD VDD VSS VSS gf180mcu_fd_sc_mcu7t5v0__fill_2
XFILLER_61_314 VDD VDD VSS VSS gf180mcu_fd_sc_mcu7t5v0__fill_2
XTAP_TAPCELL_ROW_32_707 VDD VSS gf180mcu_fd_sc_mcu7t5v0__filltie
XFILLER_70_881 VDD VDD VSS VSS gf180mcu_fd_sc_mcu7t5v0__fill_1
XFILLER_30_734 VDD VDD VSS VSS gf180mcu_fd_sc_mcu7t5v0__fill_1
XTAP_TAPCELL_ROW_12_442 VDD VSS gf180mcu_fd_sc_mcu7t5v0__filltie
XFILLER_128_688 VDD VDD VSS VSS gf180mcu_fd_sc_mcu7t5v0__fillcap_4
XFILLER_116_839 VDD VDD VSS VSS gf180mcu_fd_sc_mcu7t5v0__fill_2
XFILLER_6_473 VDD VDD VSS VSS gf180mcu_fd_sc_mcu7t5v0__fill_2
X_3470_ _3474_/A1 _3470_/A2 _4106_/Q _3471_/B VDD VDD VSS VSS gf180mcu_fd_sc_mcu7t5v0__oai21_1
XFILLER_43_4 VDD VDD VSS VSS gf180mcu_fd_sc_mcu7t5v0__fill_1
XFILLER_29_2 VDD VDD VSS VSS gf180mcu_fd_sc_mcu7t5v0__fillcap_4
X_4022_ _4022_/D input92/Z clkload9/I _4022_/Q VDD VDD VSS VSS gf180mcu_fd_sc_mcu7t5v0__dffrnq_1
XFILLER_92_472 VDD VDD VSS VSS gf180mcu_fd_sc_mcu7t5v0__fillcap_8
XFILLER_52_314 VDD VDD VSS VSS gf180mcu_fd_sc_mcu7t5v0__fill_1
XFILLER_64_174 VDD VDD VSS VSS gf180mcu_fd_sc_mcu7t5v0__fill_1
XFILLER_80_667 VDD VDD VSS VSS gf180mcu_fd_sc_mcu7t5v0__fillcap_32
XFILLER_100_27 VDD VDD VSS VSS gf180mcu_fd_sc_mcu7t5v0__fillcap_8
XFILLER_33_594 VDD VDD VSS VSS gf180mcu_fd_sc_mcu7t5v0__fillcap_16
XFILLER_20_244 VDD VDD VSS VSS gf180mcu_fd_sc_mcu7t5v0__fill_1
XFILLER_21_767 VDD VDD VSS VSS gf180mcu_fd_sc_mcu7t5v0__fill_2
X_3806_ _3806_/D _3806_/CLK _3806_/Q VDD VDD VSS VSS gf180mcu_fd_sc_mcu7t5v0__dffq_1
X_3737_ _3737_/D _3740_/CLK _3737_/Q VDD VDD VSS VSS gf180mcu_fd_sc_mcu7t5v0__dffq_1
X_1998_ _4056_/Q _3519_/A1 VDD VDD VSS VSS gf180mcu_fd_sc_mcu7t5v0__clkinv_1
XFILLER_107_839 VDD VDD VSS VSS gf180mcu_fd_sc_mcu7t5v0__fill_1
XTAP_TAPCELL_ROW_95_1525 VDD VSS gf180mcu_fd_sc_mcu7t5v0__filltie
X_3668_ _3668_/D _4167_/CLK _3668_/Q VDD VDD VSS VSS gf180mcu_fd_sc_mcu7t5v0__dffq_1
X_3599_ _3595_/Z _3596_/Z _3597_/Z _3598_/Z place74/Z _4119_/Q _3599_/Z VDD VDD VSS
+ VSS gf180mcu_fd_sc_mcu7t5v0__mux4_1
X_2619_ place83/Z _3772_/Q _2619_/S _3772_/D VDD VDD VSS VSS gf180mcu_fd_sc_mcu7t5v0__mux2_2
XFILLER_130_820 VDD VDD VSS VSS gf180mcu_fd_sc_mcu7t5v0__fill_1
XFILLER_130_831 VDD VDD VSS VSS gf180mcu_fd_sc_mcu7t5v0__fill_1
XFILLER_125_68 VDD VDD VSS VSS gf180mcu_fd_sc_mcu7t5v0__fill_2
XFILLER_102_588 VDD VDD VSS VSS gf180mcu_fd_sc_mcu7t5v0__fillcap_4
XFILLER_102_599 VDD VDD VSS VSS gf180mcu_fd_sc_mcu7t5v0__fill_1
XFILLER_68_480 VDD VDD VSS VSS gf180mcu_fd_sc_mcu7t5v0__fillcap_32
XFILLER_71_601 VDD VDD VSS VSS gf180mcu_fd_sc_mcu7t5v0__fillcap_16
XFILLER_44_815 VDD VDD VSS VSS gf180mcu_fd_sc_mcu7t5v0__fillcap_4
XFILLER_83_483 VDD VDD VSS VSS gf180mcu_fd_sc_mcu7t5v0__fillcap_4
XFILLER_44_848 VDD VDD VSS VSS gf180mcu_fd_sc_mcu7t5v0__fillcap_16
XTAP_TAPCELL_ROW_104_1643 VDD VSS gf180mcu_fd_sc_mcu7t5v0__filltie
XTAP_TAPCELL_ROW_104_1632 VDD VSS gf180mcu_fd_sc_mcu7t5v0__filltie
XFILLER_70_177 VDD VDD VSS VSS gf180mcu_fd_sc_mcu7t5v0__fillcap_16
XFILLER_24_594 VDD VDD VSS VSS gf180mcu_fd_sc_mcu7t5v0__fill_1
XFILLER_4_933 VDD VDD VSS VSS gf180mcu_fd_sc_mcu7t5v0__fill_1
XFILLER_125_658 VDD VDD VSS VSS gf180mcu_fd_sc_mcu7t5v0__fill_1
XTAP_TAPCELL_ROW_115_1783 VDD VSS gf180mcu_fd_sc_mcu7t5v0__filltie
XFILLER_3_487 VDD VDD VSS VSS gf180mcu_fd_sc_mcu7t5v0__fill_2
XFILLER_121_842 VDD VDD VSS VSS gf180mcu_fd_sc_mcu7t5v0__fillcap_32
XFILLER_94_737 VDD VDD VSS VSS gf180mcu_fd_sc_mcu7t5v0__fillcap_32
XFILLER_78_288 VDD VDD VSS VSS gf180mcu_fd_sc_mcu7t5v0__fillcap_16
XFILLER_19_311 VDD VDD VSS VSS gf180mcu_fd_sc_mcu7t5v0__fillcap_8
XFILLER_93_269 VDD VDD VSS VSS gf180mcu_fd_sc_mcu7t5v0__fillcap_4
XFILLER_75_72 VDD VDD VSS VSS gf180mcu_fd_sc_mcu7t5v0__fillcap_32
XTAP_TAPCELL_ROW_17_512 VDD VSS gf180mcu_fd_sc_mcu7t5v0__filltie
XTAP_TAPCELL_ROW_17_501 VDD VSS gf180mcu_fd_sc_mcu7t5v0__filltie
XFILLER_50_807 VDD VDD VSS VSS gf180mcu_fd_sc_mcu7t5v0__fillcap_16
XTAP_TAPCELL_ROW_66_1148 VDD VSS gf180mcu_fd_sc_mcu7t5v0__filltie
X_2970_ _4051_/Q _3931_/Q _2972_/S _3931_/D VDD VDD VSS VSS gf180mcu_fd_sc_mcu7t5v0__mux2_2
XFILLER_15_550 VDD VDD VSS VSS gf180mcu_fd_sc_mcu7t5v0__fillcap_8
XTAP_TAPCELL_ROW_45_865 VDD VSS gf180mcu_fd_sc_mcu7t5v0__filltie
XTAP_TAPCELL_ROW_45_876 VDD VSS gf180mcu_fd_sc_mcu7t5v0__filltie
X_1921_ _3895_/Q _2895_/A1 VDD VDD VSS VSS gf180mcu_fd_sc_mcu7t5v0__clkinv_1
XFILLER_43_892 VDD VDD VSS VSS gf180mcu_fd_sc_mcu7t5v0__fill_2
X_1852_ _3892_/Q _1853_/B VDD VDD VSS VSS gf180mcu_fd_sc_mcu7t5v0__clkinv_1
XFILLER_30_542 VDD VDD VSS VSS gf180mcu_fd_sc_mcu7t5v0__fillcap_8
XFILLER_30_575 VDD VDD VSS VSS gf180mcu_fd_sc_mcu7t5v0__fill_2
XFILLER_30_597 VDD VDD VSS VSS gf180mcu_fd_sc_mcu7t5v0__fillcap_4
XFILLER_128_463 VDD VDD VSS VSS gf180mcu_fd_sc_mcu7t5v0__fill_1
X_3522_ _3522_/A1 _3522_/A2 _3550_/A2 _3522_/B _4115_/D VDD VDD VSS VSS gf180mcu_fd_sc_mcu7t5v0__oai31_2
XTAP_TAPCELL_ROW_77_1288 VDD VSS gf180mcu_fd_sc_mcu7t5v0__filltie
X_3453_ _3453_/I0 _3456_/A2 _4103_/Q _3453_/Z VDD VDD VSS VSS gf180mcu_fd_sc_mcu7t5v0__mux2_2
X_2404_ place81/Z _3680_/Q _2412_/S _3680_/D VDD VDD VSS VSS gf180mcu_fd_sc_mcu7t5v0__mux2_2
XFILLER_123_190 VDD VDD VSS VSS gf180mcu_fd_sc_mcu7t5v0__fillcap_4
XTAP_TAPCELL_ROW_90_1455 VDD VSS gf180mcu_fd_sc_mcu7t5v0__filltie
XFILLER_111_352 VDD VDD VSS VSS gf180mcu_fd_sc_mcu7t5v0__fillcap_16
XFILLER_57_417 VDD VDD VSS VSS gf180mcu_fd_sc_mcu7t5v0__fill_2
X_2266_ _3928_/Q place72/Z place63/Z _3960_/Q _3968_/Q place67/Z _2267_/I VDD VDD
+ VSS VSS gf180mcu_fd_sc_mcu7t5v0__aoi222_1
XFILLER_84_225 VDD VDD VSS VSS gf180mcu_fd_sc_mcu7t5v0__fillcap_8
X_4005_ _4005_/D input92/Z _4036_/CLK _4005_/Q VDD VDD VSS VSS gf180mcu_fd_sc_mcu7t5v0__dffrnq_1
X_2197_ _3906_/Q place72/Z place63/Z _3938_/Q _2197_/C _2198_/A2 VDD VDD VSS VSS gf180mcu_fd_sc_mcu7t5v0__aoi221_1
XFILLER_84_247 VDD VDD VSS VSS gf180mcu_fd_sc_mcu7t5v0__fillcap_16
XFILLER_81_932 VDD VDD VSS VSS gf180mcu_fd_sc_mcu7t5v0__fill_2
XFILLER_38_675 VDD VDD VSS VSS gf180mcu_fd_sc_mcu7t5v0__fill_2
XFILLER_80_442 VDD VDD VSS VSS gf180mcu_fd_sc_mcu7t5v0__fillcap_8
XFILLER_80_475 VDD VDD VSS VSS gf180mcu_fd_sc_mcu7t5v0__fillcap_32
XFILLER_40_317 VDD VDD VSS VSS gf180mcu_fd_sc_mcu7t5v0__fillcap_16
XFILLER_52_144 VDD VDD VSS VSS gf180mcu_fd_sc_mcu7t5v0__fill_2
XFILLER_52_177 VDD VDD VSS VSS gf180mcu_fd_sc_mcu7t5v0__fillcap_16
XFILLER_107_658 VDD VDD VSS VSS gf180mcu_fd_sc_mcu7t5v0__fill_1
XFILLER_121_138 VDD VDD VSS VSS gf180mcu_fd_sc_mcu7t5v0__fill_2
XFILLER_103_842 VDD VDD VSS VSS gf180mcu_fd_sc_mcu7t5v0__fillcap_64
XFILLER_96_49 VDD VDD VSS VSS gf180mcu_fd_sc_mcu7t5v0__fill_1
XFILLER_96_27 VDD VDD VSS VSS gf180mcu_fd_sc_mcu7t5v0__fillcap_8
XFILLER_49_907 VDD VDD VSS VSS gf180mcu_fd_sc_mcu7t5v0__fill_2
XFILLER_130_683 VDD VDD VSS VSS gf180mcu_fd_sc_mcu7t5v0__fillcap_8
XFILLER_88_597 VDD VDD VSS VSS gf180mcu_fd_sc_mcu7t5v0__fillcap_64
XFILLER_76_737 VDD VDD VSS VSS gf180mcu_fd_sc_mcu7t5v0__fillcap_8
XFILLER_91_718 VDD VDD VSS VSS gf180mcu_fd_sc_mcu7t5v0__fill_1
XFILLER_72_932 VDD VDD VSS VSS gf180mcu_fd_sc_mcu7t5v0__fill_2
XFILLER_17_837 VDD VDD VSS VSS gf180mcu_fd_sc_mcu7t5v0__fill_2
XFILLER_17_848 VDD VDD VSS VSS gf180mcu_fd_sc_mcu7t5v0__fill_1
XFILLER_28_174 VDD VDD VSS VSS gf180mcu_fd_sc_mcu7t5v0__fill_1
XFILLER_32_807 VDD VDD VSS VSS gf180mcu_fd_sc_mcu7t5v0__fillcap_16
XFILLER_31_306 VDD VDD VSS VSS gf180mcu_fd_sc_mcu7t5v0__fillcap_4
XTAP_TAPCELL_ROW_42_835 VDD VSS gf180mcu_fd_sc_mcu7t5v0__filltie
XFILLER_12_597 VDD VDD VSS VSS gf180mcu_fd_sc_mcu7t5v0__fillcap_8
XFILLER_8_535 VDD VDD VSS VSS gf180mcu_fd_sc_mcu7t5v0__fillcap_4
XTAP_TAPCELL_ROW_22_570 VDD VSS gf180mcu_fd_sc_mcu7t5v0__filltie
XTAP_TAPCELL_ROW_61_1078 VDD VSS gf180mcu_fd_sc_mcu7t5v0__filltie
XTAP_TAPCELL_ROW_117_1812 VDD VSS gf180mcu_fd_sc_mcu7t5v0__filltie
XTAP_TAPCELL_ROW_117_1801 VDD VSS gf180mcu_fd_sc_mcu7t5v0__filltie
XFILLER_125_422 VDD VDD VSS VSS gf180mcu_fd_sc_mcu7t5v0__fillcap_32
XFILLER_113_606 VDD VDD VSS VSS gf180mcu_fd_sc_mcu7t5v0__fillcap_16
XFILLER_98_317 VDD VDD VSS VSS gf180mcu_fd_sc_mcu7t5v0__fillcap_32
XFILLER_121_650 VDD VDD VSS VSS gf180mcu_fd_sc_mcu7t5v0__fill_2
XFILLER_121_694 VDD VDD VSS VSS gf180mcu_fd_sc_mcu7t5v0__fillcap_4
XFILLER_94_523 VDD VDD VSS VSS gf180mcu_fd_sc_mcu7t5v0__fill_2
X_2120_ input97/Z _2109_/I _2134_/A1 VDD VDD VSS VSS gf180mcu_fd_sc_mcu7t5v0__nor2_1
XTAP_TAPCELL_ROW_128_1952 VDD VSS gf180mcu_fd_sc_mcu7t5v0__filltie
X_2051_ _4138_/Q _4137_/Q _2051_/A3 _2052_/A2 VDD VDD VSS VSS gf180mcu_fd_sc_mcu7t5v0__nand3_1
XFILLER_81_206 VDD VDD VSS VSS gf180mcu_fd_sc_mcu7t5v0__fillcap_4
XFILLER_35_601 VDD VDD VSS VSS gf180mcu_fd_sc_mcu7t5v0__fillcap_8
XFILLER_47_483 VDD VDD VSS VSS gf180mcu_fd_sc_mcu7t5v0__fill_1
XFILLER_63_932 VDD VDD VSS VSS gf180mcu_fd_sc_mcu7t5v0__fill_2
XFILLER_22_317 VDD VDD VSS VSS gf180mcu_fd_sc_mcu7t5v0__fillcap_64
XFILLER_34_177 VDD VDD VSS VSS gf180mcu_fd_sc_mcu7t5v0__fillcap_64
X_1904_ _2891_/A1 _4141_/Q _1907_/B2 VDD VDD VSS VSS gf180mcu_fd_sc_mcu7t5v0__nor2_1
X_2884_ place85/Z _2900_/S _2885_/B VDD VDD VSS VSS gf180mcu_fd_sc_mcu7t5v0__nand2_1
XFILLER_129_772 VDD VDD VSS VSS gf180mcu_fd_sc_mcu7t5v0__fillcap_8
X_1835_ _1819_/Z _1820_/Z _1822_/Z _1835_/B _1940_/B VDD VDD VSS VSS gf180mcu_fd_sc_mcu7t5v0__oai31_2
XTAP_TAPCELL_ROW_79_1317 VDD VSS gf180mcu_fd_sc_mcu7t5v0__filltie
XFILLER_116_499 VDD VDD VSS VSS gf180mcu_fd_sc_mcu7t5v0__fillcap_16
XFILLER_103_138 VDD VDD VSS VSS gf180mcu_fd_sc_mcu7t5v0__fill_2
X_3436_ _4099_/Q _3443_/B _3437_/A2 VDD VDD VSS VSS gf180mcu_fd_sc_mcu7t5v0__nor2_1
X_3367_ _4083_/Q _3370_/A1 _3368_/B VDD VDD VSS VSS gf180mcu_fd_sc_mcu7t5v0__nand2_1
XFILLER_58_715 VDD VDD VSS VSS gf180mcu_fd_sc_mcu7t5v0__fillcap_4
XFILLER_111_182 VDD VDD VSS VSS gf180mcu_fd_sc_mcu7t5v0__fillcap_16
XFILLER_58_737 VDD VDD VSS VSS gf180mcu_fd_sc_mcu7t5v0__fillcap_64
XFILLER_100_856 VDD VDD VSS VSS gf180mcu_fd_sc_mcu7t5v0__fillcap_4
XFILLER_73_718 VDD VDD VSS VSS gf180mcu_fd_sc_mcu7t5v0__fillcap_8
X_2249_ _2249_/I _2249_/ZN VDD VDD VSS VSS gf180mcu_fd_sc_mcu7t5v0__inv_1
XFILLER_54_932 VDD VDD VSS VSS gf180mcu_fd_sc_mcu7t5v0__fill_2
XFILLER_122_69 VDD VDD VSS VSS gf180mcu_fd_sc_mcu7t5v0__fillcap_32
XFILLER_53_442 VDD VDD VSS VSS gf180mcu_fd_sc_mcu7t5v0__fillcap_16
XFILLER_14_807 VDD VDD VSS VSS gf180mcu_fd_sc_mcu7t5v0__fillcap_8
XTAP_TAPCELL_ROW_0_276 VDD VSS gf180mcu_fd_sc_mcu7t5v0__filltie
XTAP_TAPCELL_ROW_0_287 VDD VSS gf180mcu_fd_sc_mcu7t5v0__filltie
XFILLER_26_667 VDD VDD VSS VSS gf180mcu_fd_sc_mcu7t5v0__fillcap_16
XTAP_TAPCELL_ROW_101_1602 VDD VSS gf180mcu_fd_sc_mcu7t5v0__filltie
XFILLER_80_283 VDD VDD VSS VSS gf180mcu_fd_sc_mcu7t5v0__fill_1
XFILLER_41_626 VDD VDD VSS VSS gf180mcu_fd_sc_mcu7t5v0__fillcap_4
XFILLER_40_136 VDD VDD VSS VSS gf180mcu_fd_sc_mcu7t5v0__fillcap_32
XFILLER_119_282 VDD VDD VSS VSS gf180mcu_fd_sc_mcu7t5v0__fill_2
XFILLER_108_923 VDD VDD VSS VSS gf180mcu_fd_sc_mcu7t5v0__fillcap_8
XFILLER_107_422 VDD VDD VSS VSS gf180mcu_fd_sc_mcu7t5v0__fillcap_64
XFILLER_107_400 VDD VDD VSS VSS gf180mcu_fd_sc_mcu7t5v0__fill_1
XFILLER_31_66 VDD VDD VSS VSS gf180mcu_fd_sc_mcu7t5v0__fillcap_4
XFILLER_122_403 VDD VDD VSS VSS gf180mcu_fd_sc_mcu7t5v0__fill_1
XTAP_TAPCELL_ROW_112_1742 VDD VSS gf180mcu_fd_sc_mcu7t5v0__filltie
XFILLER_89_884 VDD VDD VSS VSS gf180mcu_fd_sc_mcu7t5v0__fillcap_16
Xinput111 hold206/Z _3119_/I1 VDD VDD VSS VSS gf180mcu_fd_sc_mcu7t5v0__dlyb_1
XTAP_TAPCELL_ROW_8_387 VDD VSS gf180mcu_fd_sc_mcu7t5v0__filltie
Xinput100 hold202/Z _3084_/I1 VDD VDD VSS VSS gf180mcu_fd_sc_mcu7t5v0__dlyb_1
XFILLER_1_766 VDD VDD VSS VSS gf180mcu_fd_sc_mcu7t5v0__fillcap_4
Xinput133 hold195/Z _3160_/I1 VDD VDD VSS VSS gf180mcu_fd_sc_mcu7t5v0__dlyb_1
Xinput122 hold227/Z _3140_/I1 VDD VDD VSS VSS gf180mcu_fd_sc_mcu7t5v0__dlyb_1
XFILLER_88_383 VDD VDD VSS VSS gf180mcu_fd_sc_mcu7t5v0__fill_2
XFILLER_76_512 VDD VDD VSS VSS gf180mcu_fd_sc_mcu7t5v0__fillcap_4
XFILLER_48_247 VDD VDD VSS VSS gf180mcu_fd_sc_mcu7t5v0__fillcap_16
XFILLER_45_932 VDD VDD VSS VSS gf180mcu_fd_sc_mcu7t5v0__fill_2
XTAP_TAPCELL_ROW_27_640 VDD VSS gf180mcu_fd_sc_mcu7t5v0__filltie
XFILLER_44_453 VDD VDD VSS VSS gf180mcu_fd_sc_mcu7t5v0__fill_2
XTAP_TAPCELL_ROW_63_1107 VDD VSS gf180mcu_fd_sc_mcu7t5v0__filltie
XTAP_TAPCELL_ROW_123_1882 VDD VSS gf180mcu_fd_sc_mcu7t5v0__filltie
XFILLER_16_177 VDD VDD VSS VSS gf180mcu_fd_sc_mcu7t5v0__fillcap_8
XFILLER_31_114 VDD VDD VSS VSS gf180mcu_fd_sc_mcu7t5v0__fillcap_16
XFILLER_71_261 VDD VDD VSS VSS gf180mcu_fd_sc_mcu7t5v0__fill_2
XFILLER_72_84 VDD VDD VSS VSS gf180mcu_fd_sc_mcu7t5v0__fillcap_16
XFILLER_8_387 VDD VDD VSS VSS gf180mcu_fd_sc_mcu7t5v0__fillcap_16
XFILLER_99_659 VDD VDD VSS VSS gf180mcu_fd_sc_mcu7t5v0__fill_2
XTAP_TAPCELL_ROW_74_1247 VDD VSS gf180mcu_fd_sc_mcu7t5v0__filltie
X_3221_ _4049_/Q _4017_/Q _4129_/D _4049_/D VDD VDD VSS VSS gf180mcu_fd_sc_mcu7t5v0__mux2_2
XFILLER_86_309 VDD VDD VSS VSS gf180mcu_fd_sc_mcu7t5v0__fillcap_4
X_3152_ _4016_/Q _3152_/I1 _3160_/S _4016_/D VDD VDD VSS VSS gf180mcu_fd_sc_mcu7t5v0__mux2_2
X_2103_ _3709_/Q _3717_/Q _3725_/Q _3733_/Q place79/Z place78/Z _2103_/Z VDD VDD VSS
+ VSS gf180mcu_fd_sc_mcu7t5v0__mux4_1
XFILLER_11_2 VDD VDD VSS VSS gf180mcu_fd_sc_mcu7t5v0__fillcap_64
XFILLER_67_556 VDD VDD VSS VSS gf180mcu_fd_sc_mcu7t5v0__fillcap_4
X_3083_ _3083_/A1 _3083_/A2 _4129_/D _3982_/D VDD VDD VSS VSS gf180mcu_fd_sc_mcu7t5v0__aoi21_1
X_2034_ _2008_/Z _2034_/A2 _2034_/B _4135_/D VDD VDD VSS VSS gf180mcu_fd_sc_mcu7t5v0__oai21_4
XFILLER_82_559 VDD VDD VSS VSS gf180mcu_fd_sc_mcu7t5v0__fillcap_16
XTAP_TAPCELL_ROW_85_1387 VDD VSS gf180mcu_fd_sc_mcu7t5v0__filltie
X_3985_ _3985_/D input92/Z _4129_/CLK _3985_/Q VDD VDD VSS VSS gf180mcu_fd_sc_mcu7t5v0__dffrnq_1
XFILLER_50_445 VDD VDD VSS VSS gf180mcu_fd_sc_mcu7t5v0__fillcap_8
X_2867_ place83/Z _3884_/Q _2867_/S _3884_/D VDD VDD VSS VSS gf180mcu_fd_sc_mcu7t5v0__mux2_2
X_1818_ _1943_/B2 _4144_/Q _1824_/I1 VDD VDD VSS VSS gf180mcu_fd_sc_mcu7t5v0__nand2_1
XPHY_EDGE_ROW_68_Left_201 VDD VSS gf180mcu_fd_sc_mcu7t5v0__endcap
XFILLER_89_125 VDD VDD VSS VSS gf180mcu_fd_sc_mcu7t5v0__fillcap_8
XFILLER_104_469 VDD VDD VSS VSS gf180mcu_fd_sc_mcu7t5v0__fill_1
X_3419_ _4103_/Q _4104_/Q _3419_/Z VDD VDD VSS VSS gf180mcu_fd_sc_mcu7t5v0__xor2_1
XFILLER_100_620 VDD VDD VSS VSS gf180mcu_fd_sc_mcu7t5v0__fill_1
XFILLER_98_692 VDD VDD VSS VSS gf180mcu_fd_sc_mcu7t5v0__fill_1
XFILLER_86_843 VDD VDD VSS VSS gf180mcu_fd_sc_mcu7t5v0__fill_2
XTAP_TAPCELL_ROW_5_346 VDD VSS gf180mcu_fd_sc_mcu7t5v0__filltie
XFILLER_58_512 VDD VDD VSS VSS gf180mcu_fd_sc_mcu7t5v0__fillcap_4
XFILLER_112_491 VDD VDD VSS VSS gf180mcu_fd_sc_mcu7t5v0__fillcap_16
XFILLER_100_631 VDD VDD VSS VSS gf180mcu_fd_sc_mcu7t5v0__fillcap_32
XTAP_TAPCELL_ROW_5_357 VDD VSS gf180mcu_fd_sc_mcu7t5v0__filltie
XFILLER_58_556 VDD VDD VSS VSS gf180mcu_fd_sc_mcu7t5v0__fillcap_16
XPHY_EDGE_ROW_77_Left_210 VDD VSS gf180mcu_fd_sc_mcu7t5v0__endcap
XFILLER_58_578 VDD VDD VSS VSS gf180mcu_fd_sc_mcu7t5v0__fill_1
XFILLER_27_932 VDD VDD VSS VSS gf180mcu_fd_sc_mcu7t5v0__fill_2
XFILLER_39_792 VDD VDD VSS VSS gf180mcu_fd_sc_mcu7t5v0__fill_2
XFILLER_42_913 VDD VDD VSS VSS gf180mcu_fd_sc_mcu7t5v0__fillcap_16
XFILLER_60_209 VDD VDD VSS VSS gf180mcu_fd_sc_mcu7t5v0__fillcap_4
XFILLER_13_103 VDD VDD VSS VSS gf180mcu_fd_sc_mcu7t5v0__fillcap_32
XTAP_TAPCELL_ROW_52_963 VDD VSS gf180mcu_fd_sc_mcu7t5v0__filltie
XFILLER_108_753 VDD VDD VSS VSS gf180mcu_fd_sc_mcu7t5v0__fillcap_4
XFILLER_123_767 VDD VDD VSS VSS gf180mcu_fd_sc_mcu7t5v0__fill_2
XFILLER_1_552 VDD VDD VSS VSS gf180mcu_fd_sc_mcu7t5v0__fillcap_8
XFILLER_107_80 VDD VDD VSS VSS gf180mcu_fd_sc_mcu7t5v0__fill_2
XFILLER_95_139 VDD VDD VSS VSS gf180mcu_fd_sc_mcu7t5v0__fill_1
XFILLER_49_578 VDD VDD VSS VSS gf180mcu_fd_sc_mcu7t5v0__fillcap_8
XTAP_TAPCELL_ROW_125_1911 VDD VSS gf180mcu_fd_sc_mcu7t5v0__filltie
XFILLER_91_334 VDD VDD VSS VSS gf180mcu_fd_sc_mcu7t5v0__fill_2
XFILLER_76_397 VDD VDD VSS VSS gf180mcu_fd_sc_mcu7t5v0__fill_1
XFILLER_83_72 VDD VDD VSS VSS gf180mcu_fd_sc_mcu7t5v0__fillcap_4
XFILLER_17_486 VDD VDD VSS VSS gf180mcu_fd_sc_mcu7t5v0__fillcap_4
X_3770_ _3770_/D _3877_/CLK _3770_/Q VDD VDD VSS VSS gf180mcu_fd_sc_mcu7t5v0__dffq_1
XPHY_EDGE_ROW_132_Right_132 VDD VSS gf180mcu_fd_sc_mcu7t5v0__endcap
XFILLER_73_4 VDD VDD VSS VSS gf180mcu_fd_sc_mcu7t5v0__fill_1
XTAP_TAPCELL_ROW_30_679 VDD VSS gf180mcu_fd_sc_mcu7t5v0__filltie
X_2652_ place86/Z _3785_/Q _2658_/S _3785_/D VDD VDD VSS VSS gf180mcu_fd_sc_mcu7t5v0__mux2_2
XFILLER_59_2 VDD VDD VSS VSS gf180mcu_fd_sc_mcu7t5v0__fillcap_8
X_3204_ _4041_/Q _4009_/Q _4129_/D _4041_/D VDD VDD VSS VSS gf180mcu_fd_sc_mcu7t5v0__mux2_2
XFILLER_113_266 VDD VDD VSS VSS gf180mcu_fd_sc_mcu7t5v0__fill_1
XFILLER_79_191 VDD VDD VSS VSS gf180mcu_fd_sc_mcu7t5v0__fillcap_16
XTAP_TAPCELL_ROW_87_1416 VDD VSS gf180mcu_fd_sc_mcu7t5v0__filltie
XTAP_TAPCELL_ROW_2_316 VDD VSS gf180mcu_fd_sc_mcu7t5v0__filltie
XFILLER_55_504 VDD VDD VSS VSS gf180mcu_fd_sc_mcu7t5v0__fillcap_16
X_3066_ _3495_/B _3066_/A2 _3973_/D VDD VDD VSS VSS gf180mcu_fd_sc_mcu7t5v0__nor2_1
X_2017_ _2008_/Z _2017_/A2 _2017_/B _4132_/D VDD VDD VSS VSS gf180mcu_fd_sc_mcu7t5v0__oai21_4
XTAP_TAPCELL_ROW_38_779 VDD VSS gf180mcu_fd_sc_mcu7t5v0__filltie
XFILLER_23_434 VDD VDD VSS VSS gf180mcu_fd_sc_mcu7t5v0__fill_2
X_3968_ _3968_/D _2279_/I _3968_/CLK _3968_/Q VDD VDD VSS VSS gf180mcu_fd_sc_mcu7t5v0__dffrnq_1
X_3899_ _3899_/D _4157_/RN _4145_/CLK _3899_/Q VDD VDD VSS VSS gf180mcu_fd_sc_mcu7t5v0__dffrnq_1
XTAP_TAPCELL_ROW_98_1556 VDD VSS gf180mcu_fd_sc_mcu7t5v0__filltie
XFILLER_2_305 VDD VDD VSS VSS gf180mcu_fd_sc_mcu7t5v0__fillcap_8
XFILLER_104_211 VDD VDD VSS VSS gf180mcu_fd_sc_mcu7t5v0__fillcap_32
Xhold195 s_axi_wdata[31] hold195/Z VDD VDD VSS VSS gf180mcu_fd_sc_mcu7t5v0__dlyc_1
XFILLER_132_575 VDD VDD VSS VSS gf180mcu_fd_sc_mcu7t5v0__fill_2
XFILLER_77_139 VDD VDD VSS VSS gf180mcu_fd_sc_mcu7t5v0__fill_1
XFILLER_58_331 VDD VDD VSS VSS gf180mcu_fd_sc_mcu7t5v0__fillcap_32
XFILLER_59_887 VDD VDD VSS VSS gf180mcu_fd_sc_mcu7t5v0__fillcap_16
XFILLER_15_902 VDD VDD VSS VSS gf180mcu_fd_sc_mcu7t5v0__fillcap_8
XFILLER_37_87 VDD VDD VSS VSS gf180mcu_fd_sc_mcu7t5v0__fillcap_32
XTAP_TAPCELL_ROW_107_1674 VDD VSS gf180mcu_fd_sc_mcu7t5v0__filltie
XFILLER_42_732 VDD VDD VSS VSS gf180mcu_fd_sc_mcu7t5v0__fill_2
XTAP_TAPCELL_ROW_120_1852 VDD VSS gf180mcu_fd_sc_mcu7t5v0__filltie
XTAP_TAPCELL_ROW_120_1841 VDD VSS gf180mcu_fd_sc_mcu7t5v0__filltie
XFILLER_14_489 VDD VDD VSS VSS gf180mcu_fd_sc_mcu7t5v0__fillcap_4
XFILLER_127_347 VDD VDD VSS VSS gf180mcu_fd_sc_mcu7t5v0__fill_2
XTAP_TAPCELL_ROW_58_1039 VDD VSS gf180mcu_fd_sc_mcu7t5v0__filltie
XFILLER_45_8 VDD VDD VSS VSS gf180mcu_fd_sc_mcu7t5v0__fill_1
XFILLER_69_618 VDD VDD VSS VSS gf180mcu_fd_sc_mcu7t5v0__fillcap_8
XTAP_TAPCELL_ROW_71_1206 VDD VSS gf180mcu_fd_sc_mcu7t5v0__filltie
XTAP_TAPCELL_ROW_131_1992 VDD VSS gf180mcu_fd_sc_mcu7t5v0__filltie
XFILLER_1_360 VDD VDD VSS VSS gf180mcu_fd_sc_mcu7t5v0__fill_2
XFILLER_110_247 VDD VDD VSS VSS gf180mcu_fd_sc_mcu7t5v0__fillcap_16
XFILLER_77_651 VDD VDD VSS VSS gf180mcu_fd_sc_mcu7t5v0__fillcap_32
XFILLER_49_342 VDD VDD VSS VSS gf180mcu_fd_sc_mcu7t5v0__fillcap_8
XFILLER_92_643 VDD VDD VSS VSS gf180mcu_fd_sc_mcu7t5v0__fillcap_8
XFILLER_91_142 VDD VDD VSS VSS gf180mcu_fd_sc_mcu7t5v0__fillcap_32
XTAP_TAPCELL_ROW_69_1179 VDD VSS gf180mcu_fd_sc_mcu7t5v0__filltie
XTAP_TAPCELL_ROW_35_738 VDD VSS gf180mcu_fd_sc_mcu7t5v0__filltie
XTAP_TAPCELL_ROW_82_1357 VDD VSS gf180mcu_fd_sc_mcu7t5v0__filltie
XTAP_TAPCELL_ROW_82_1346 VDD VSS gf180mcu_fd_sc_mcu7t5v0__filltie
X_3822_ _3822_/D _4153_/CLK _3822_/Q VDD VDD VSS VSS gf180mcu_fd_sc_mcu7t5v0__dffq_1
XFILLER_60_584 VDD VDD VSS VSS gf180mcu_fd_sc_mcu7t5v0__fillcap_8
XTAP_TAPCELL_ROW_15_484 VDD VSS gf180mcu_fd_sc_mcu7t5v0__filltie
X_3753_ _3753_/D _4108_/CLK _3753_/Q VDD VDD VSS VSS gf180mcu_fd_sc_mcu7t5v0__dffq_1
X_2704_ place86/Z _3809_/Q _2710_/S _3809_/D VDD VDD VSS VSS gf180mcu_fd_sc_mcu7t5v0__mux2_2
X_3684_ _3684_/D _4167_/CLK _3684_/Q VDD VDD VSS VSS gf180mcu_fd_sc_mcu7t5v0__dffq_1
X_2566_ _3752_/Q place81/Z _2574_/S _3752_/D VDD VDD VSS VSS gf180mcu_fd_sc_mcu7t5v0__mux2_2
XFILLER_114_597 VDD VDD VSS VSS gf180mcu_fd_sc_mcu7t5v0__fill_2
XFILLER_102_737 VDD VDD VSS VSS gf180mcu_fd_sc_mcu7t5v0__fillcap_64
XTAP_TAPCELL_ROW_93_1497 VDD VSS gf180mcu_fd_sc_mcu7t5v0__filltie
X_2497_ _3721_/Q _4071_/Q _2503_/S _3721_/D VDD VDD VSS VSS gf180mcu_fd_sc_mcu7t5v0__mux2_2
XFILLER_114_37 VDD VDD VSS VSS gf180mcu_fd_sc_mcu7t5v0__fillcap_8
XFILLER_101_269 VDD VDD VSS VSS gf180mcu_fd_sc_mcu7t5v0__fillcap_8
XFILLER_83_610 VDD VDD VSS VSS gf180mcu_fd_sc_mcu7t5v0__fillcap_16
X_4167_ _4167_/D input92/Z _4167_/CLK _4167_/Q VDD VDD VSS VSS gf180mcu_fd_sc_mcu7t5v0__dffrnq_1
XFILLER_56_802 VDD VDD VSS VSS gf180mcu_fd_sc_mcu7t5v0__fill_2
XFILLER_95_492 VDD VDD VSS VSS gf180mcu_fd_sc_mcu7t5v0__fillcap_64
X_4098_ _4098_/D _2279_/I _4098_/CLK _4098_/Q VDD VDD VSS VSS gf180mcu_fd_sc_mcu7t5v0__dffrnq_1
XFILLER_71_816 VDD VDD VSS VSS gf180mcu_fd_sc_mcu7t5v0__fill_2
XFILLER_56_868 VDD VDD VSS VSS gf180mcu_fd_sc_mcu7t5v0__fillcap_4
XFILLER_36_592 VDD VDD VSS VSS gf180mcu_fd_sc_mcu7t5v0__fill_2
XFILLER_12_927 VDD VDD VSS VSS gf180mcu_fd_sc_mcu7t5v0__fillcap_4
XFILLER_11_404 VDD VDD VSS VSS gf180mcu_fd_sc_mcu7t5v0__fillcap_16
XFILLER_51_562 VDD VDD VSS VSS gf180mcu_fd_sc_mcu7t5v0__fillcap_16
XFILLER_8_909 VDD VDD VSS VSS gf180mcu_fd_sc_mcu7t5v0__fillcap_16
XFILLER_7_419 VDD VDD VSS VSS gf180mcu_fd_sc_mcu7t5v0__fill_1
XFILLER_124_317 VDD VDD VSS VSS gf180mcu_fd_sc_mcu7t5v0__fillcap_32
XFILLER_3_614 VDD VDD VSS VSS gf180mcu_fd_sc_mcu7t5v0__fill_1
XFILLER_105_553 VDD VDD VSS VSS gf180mcu_fd_sc_mcu7t5v0__fillcap_4
XFILLER_120_523 VDD VDD VSS VSS gf180mcu_fd_sc_mcu7t5v0__fill_2
XTAP_TAPCELL_ROW_109_1703 VDD VSS gf180mcu_fd_sc_mcu7t5v0__filltie
XFILLER_74_621 VDD VDD VSS VSS gf180mcu_fd_sc_mcu7t5v0__fill_2
XFILLER_47_857 VDD VDD VSS VSS gf180mcu_fd_sc_mcu7t5v0__fillcap_8
XFILLER_58_161 VDD VDD VSS VSS gf180mcu_fd_sc_mcu7t5v0__fillcap_8
XFILLER_73_142 VDD VDD VSS VSS gf180mcu_fd_sc_mcu7t5v0__fillcap_16
XFILLER_34_518 VDD VDD VSS VSS gf180mcu_fd_sc_mcu7t5v0__fillcap_4
XFILLER_46_378 VDD VDD VSS VSS gf180mcu_fd_sc_mcu7t5v0__fillcap_4
XPHY_EDGE_ROW_14_Left_147 VDD VSS gf180mcu_fd_sc_mcu7t5v0__endcap
XFILLER_64_85 VDD VDD VSS VSS gf180mcu_fd_sc_mcu7t5v0__fillcap_16
XFILLER_14_242 VDD VDD VSS VSS gf180mcu_fd_sc_mcu7t5v0__fill_2
XTAP_TAPCELL_ROW_32_708 VDD VSS gf180mcu_fd_sc_mcu7t5v0__filltie
XFILLER_30_724 VDD VDD VSS VSS gf180mcu_fd_sc_mcu7t5v0__fillcap_8
XFILLER_80_84 VDD VDD VSS VSS gf180mcu_fd_sc_mcu7t5v0__fillcap_16
XTAP_TAPCELL_ROW_12_443 VDD VSS gf180mcu_fd_sc_mcu7t5v0__filltie
XFILLER_128_667 VDD VDD VSS VSS gf180mcu_fd_sc_mcu7t5v0__fillcap_4
XFILLER_116_807 VDD VDD VSS VSS gf180mcu_fd_sc_mcu7t5v0__fillcap_32
XFILLER_109_881 VDD VDD VSS VSS gf180mcu_fd_sc_mcu7t5v0__fill_2
X_2420_ _3687_/Q _4069_/Q _2430_/S _3687_/D VDD VDD VSS VSS gf180mcu_fd_sc_mcu7t5v0__mux2_2
XFILLER_124_862 VDD VDD VSS VSS gf180mcu_fd_sc_mcu7t5v0__fillcap_8
XFILLER_97_702 VDD VDD VSS VSS gf180mcu_fd_sc_mcu7t5v0__fillcap_16
XPHY_EDGE_ROW_23_Left_156 VDD VSS gf180mcu_fd_sc_mcu7t5v0__endcap
XFILLER_97_724 VDD VDD VSS VSS gf180mcu_fd_sc_mcu7t5v0__fill_1
X_2351_ _3657_/Q _4071_/Q _2357_/S _3657_/D VDD VDD VSS VSS gf180mcu_fd_sc_mcu7t5v0__mux2_2
XFILLER_111_534 VDD VDD VSS VSS gf180mcu_fd_sc_mcu7t5v0__fill_1
X_2282_ _4097_/Q _4098_/Q _2540_/A1 place62/I VDD VDD VSS VSS gf180mcu_fd_sc_mcu7t5v0__nor3_1
XFILLER_38_802 VDD VDD VSS VSS gf180mcu_fd_sc_mcu7t5v0__fill_2
X_4021_ _4021_/D input92/Z clkload9/I _4021_/Q VDD VDD VSS VSS gf180mcu_fd_sc_mcu7t5v0__dffrnq_1
XFILLER_77_492 VDD VDD VSS VSS gf180mcu_fd_sc_mcu7t5v0__fillcap_16
XFILLER_65_632 VDD VDD VSS VSS gf180mcu_fd_sc_mcu7t5v0__fillcap_64
XFILLER_92_462 VDD VDD VSS VSS gf180mcu_fd_sc_mcu7t5v0__fillcap_4
XPHY_EDGE_ROW_32_Left_165 VDD VSS gf180mcu_fd_sc_mcu7t5v0__endcap
XFILLER_53_838 VDD VDD VSS VSS gf180mcu_fd_sc_mcu7t5v0__fill_2
XFILLER_21_702 VDD VDD VSS VSS gf180mcu_fd_sc_mcu7t5v0__fillcap_8
XFILLER_33_562 VDD VDD VSS VSS gf180mcu_fd_sc_mcu7t5v0__fillcap_32
X_3805_ _3805_/D _3806_/CLK _3805_/Q VDD VDD VSS VSS gf180mcu_fd_sc_mcu7t5v0__dffq_1
X_3736_ _3736_/D _3738_/CLK _3736_/Q VDD VDD VSS VSS gf180mcu_fd_sc_mcu7t5v0__dffq_1
XFILLER_107_829 VDD VDD VSS VSS gf180mcu_fd_sc_mcu7t5v0__fillcap_8
XTAP_TAPCELL_ROW_95_1526 VDD VSS gf180mcu_fd_sc_mcu7t5v0__filltie
XTAP_TAPCELL_ROW_95_1515 VDD VSS gf180mcu_fd_sc_mcu7t5v0__filltie
XFILLER_106_317 VDD VDD VSS VSS gf180mcu_fd_sc_mcu7t5v0__fillcap_8
X_3667_ _3667_/D _3732_/CLK _3667_/Q VDD VDD VSS VSS gf180mcu_fd_sc_mcu7t5v0__dffq_1
XPHY_EDGE_ROW_41_Left_174 VDD VSS gf180mcu_fd_sc_mcu7t5v0__endcap
X_3598_ _3788_/Q _3796_/Q _3804_/Q _3812_/Q place76/Z place75/Z _3598_/Z VDD VDD VSS
+ VSS gf180mcu_fd_sc_mcu7t5v0__mux4_1
XFILLER_115_895 VDD VDD VSS VSS gf180mcu_fd_sc_mcu7t5v0__fillcap_8
XFILLER_114_361 VDD VDD VSS VSS gf180mcu_fd_sc_mcu7t5v0__fill_1
XFILLER_87_212 VDD VDD VSS VSS gf180mcu_fd_sc_mcu7t5v0__fill_1
XFILLER_28_312 VDD VDD VSS VSS gf180mcu_fd_sc_mcu7t5v0__fill_2
XPHY_EDGE_ROW_50_Left_183 VDD VSS gf180mcu_fd_sc_mcu7t5v0__endcap
XFILLER_55_142 VDD VDD VSS VSS gf180mcu_fd_sc_mcu7t5v0__fillcap_64
XFILLER_43_326 VDD VDD VSS VSS gf180mcu_fd_sc_mcu7t5v0__fill_2
XFILLER_70_101 VDD VDD VSS VSS gf180mcu_fd_sc_mcu7t5v0__fillcap_4
XTAP_TAPCELL_ROW_104_1633 VDD VSS gf180mcu_fd_sc_mcu7t5v0__filltie
XTAP_TAPCELL_ROW_104_1644 VDD VSS gf180mcu_fd_sc_mcu7t5v0__filltie
XFILLER_11_212 VDD VDD VSS VSS gf180mcu_fd_sc_mcu7t5v0__fillcap_8
XFILLER_126_2 VDD VDD VSS VSS gf180mcu_fd_sc_mcu7t5v0__fillcap_16
XFILLER_125_648 VDD VDD VSS VSS gf180mcu_fd_sc_mcu7t5v0__fillcap_8
XFILLER_125_626 VDD VDD VSS VSS gf180mcu_fd_sc_mcu7t5v0__fillcap_4
XFILLER_3_422 VDD VDD VSS VSS gf180mcu_fd_sc_mcu7t5v0__fillcap_16
XTAP_TAPCELL_ROW_115_1784 VDD VSS gf180mcu_fd_sc_mcu7t5v0__filltie
XFILLER_79_702 VDD VDD VSS VSS gf180mcu_fd_sc_mcu7t5v0__fillcap_16
XFILLER_78_223 VDD VDD VSS VSS gf180mcu_fd_sc_mcu7t5v0__fill_1
XFILLER_78_256 VDD VDD VSS VSS gf180mcu_fd_sc_mcu7t5v0__fillcap_32
XFILLER_59_96 VDD VDD VSS VSS gf180mcu_fd_sc_mcu7t5v0__fillcap_4
XFILLER_47_632 VDD VDD VSS VSS gf180mcu_fd_sc_mcu7t5v0__fillcap_64
XFILLER_59_492 VDD VDD VSS VSS gf180mcu_fd_sc_mcu7t5v0__fill_2
XFILLER_66_429 VDD VDD VSS VSS gf180mcu_fd_sc_mcu7t5v0__fillcap_16
XFILLER_19_334 VDD VDD VSS VSS gf180mcu_fd_sc_mcu7t5v0__fillcap_16
XFILLER_19_356 VDD VDD VSS VSS gf180mcu_fd_sc_mcu7t5v0__fill_1
XFILLER_90_933 VDD VDD VSS VSS gf180mcu_fd_sc_mcu7t5v0__fill_1
XTAP_TAPCELL_ROW_17_502 VDD VSS gf180mcu_fd_sc_mcu7t5v0__filltie
XFILLER_62_613 VDD VDD VSS VSS gf180mcu_fd_sc_mcu7t5v0__fillcap_8
XTAP_TAPCELL_ROW_17_513 VDD VSS gf180mcu_fd_sc_mcu7t5v0__filltie
XTAP_TAPCELL_ROW_66_1138 VDD VSS gf180mcu_fd_sc_mcu7t5v0__filltie
XTAP_TAPCELL_ROW_66_1149 VDD VSS gf180mcu_fd_sc_mcu7t5v0__filltie
XTAP_TAPCELL_ROW_45_866 VDD VSS gf180mcu_fd_sc_mcu7t5v0__filltie
XTAP_TAPCELL_ROW_45_877 VDD VSS gf180mcu_fd_sc_mcu7t5v0__filltie
X_1920_ _3896_/Q _4143_/Q _1920_/Z VDD VDD VSS VSS gf180mcu_fd_sc_mcu7t5v0__xor2_1
XFILLER_91_72 VDD VDD VSS VSS gf180mcu_fd_sc_mcu7t5v0__fillcap_16
XFILLER_30_554 VDD VDD VSS VSS gf180mcu_fd_sc_mcu7t5v0__fill_2
XFILLER_129_932 VDD VDD VSS VSS gf180mcu_fd_sc_mcu7t5v0__fill_2
X_3521_ _4115_/Q _3522_/B VDD VDD VSS VSS gf180mcu_fd_sc_mcu7t5v0__clkinv_1
XFILLER_7_772 VDD VDD VSS VSS gf180mcu_fd_sc_mcu7t5v0__fillcap_64
XFILLER_115_158 VDD VDD VSS VSS gf180mcu_fd_sc_mcu7t5v0__fillcap_8
XFILLER_115_136 VDD VDD VSS VSS gf180mcu_fd_sc_mcu7t5v0__fillcap_4
XTAP_TAPCELL_ROW_77_1289 VDD VSS gf180mcu_fd_sc_mcu7t5v0__filltie
X_3452_ _3449_/C _3906_/Q _3452_/B _3456_/A2 VDD VDD VSS VSS gf180mcu_fd_sc_mcu7t5v0__aoi21_1
XFILLER_131_629 VDD VDD VSS VSS gf180mcu_fd_sc_mcu7t5v0__fill_1
X_3383_ _4087_/Q _3383_/A2 _4087_/D VDD VDD VSS VSS gf180mcu_fd_sc_mcu7t5v0__xor2_2
XFILLER_41_2 VDD VDD VSS VSS gf180mcu_fd_sc_mcu7t5v0__fillcap_64
XTAP_TAPCELL_ROW_90_1456 VDD VSS gf180mcu_fd_sc_mcu7t5v0__filltie
X_2334_ place80/Z _3650_/Q _2338_/S _3650_/D VDD VDD VSS VSS gf180mcu_fd_sc_mcu7t5v0__mux2_2
XFILLER_69_212 VDD VDD VSS VSS gf180mcu_fd_sc_mcu7t5v0__fillcap_64
X_2265_ _2265_/I _2265_/ZN VDD VDD VSS VSS gf180mcu_fd_sc_mcu7t5v0__inv_1
X_4004_ _4004_/D input92/Z _4036_/CLK _4004_/Q VDD VDD VSS VSS gf180mcu_fd_sc_mcu7t5v0__dffrnq_1
X_2196_ _2112_/I _1892_/C _2219_/B _2196_/C _2197_/C VDD VDD VSS VSS gf180mcu_fd_sc_mcu7t5v0__aoi211_1
XFILLER_37_142 VDD VDD VSS VSS gf180mcu_fd_sc_mcu7t5v0__fillcap_8
XFILLER_65_484 VDD VDD VSS VSS gf180mcu_fd_sc_mcu7t5v0__fillcap_4
XFILLER_80_465 VDD VDD VSS VSS gf180mcu_fd_sc_mcu7t5v0__fill_2
XFILLER_80_454 VDD VDD VSS VSS gf180mcu_fd_sc_mcu7t5v0__fill_1
XFILLER_21_554 VDD VDD VSS VSS gf180mcu_fd_sc_mcu7t5v0__fillcap_4
XFILLER_119_486 VDD VDD VSS VSS gf180mcu_fd_sc_mcu7t5v0__fillcap_4
XFILLER_107_626 VDD VDD VSS VSS gf180mcu_fd_sc_mcu7t5v0__fillcap_4
X_3719_ _3719_/D _3729_/CLK _3719_/Q VDD VDD VSS VSS gf180mcu_fd_sc_mcu7t5v0__dffq_1
XFILLER_107_648 VDD VDD VSS VSS gf180mcu_fd_sc_mcu7t5v0__fill_1
XFILLER_122_629 VDD VDD VSS VSS gf180mcu_fd_sc_mcu7t5v0__fillcap_16
XFILLER_121_117 VDD VDD VSS VSS gf180mcu_fd_sc_mcu7t5v0__fill_2
XFILLER_115_692 VDD VDD VSS VSS gf180mcu_fd_sc_mcu7t5v0__fillcap_8
XFILLER_88_521 VDD VDD VSS VSS gf180mcu_fd_sc_mcu7t5v0__fillcap_4
XFILLER_76_749 VDD VDD VSS VSS gf180mcu_fd_sc_mcu7t5v0__fill_1
XFILLER_29_88 VDD VDD VSS VSS gf180mcu_fd_sc_mcu7t5v0__fillcap_8
XFILLER_29_632 VDD VDD VSS VSS gf180mcu_fd_sc_mcu7t5v0__fillcap_16
XFILLER_56_440 VDD VDD VSS VSS gf180mcu_fd_sc_mcu7t5v0__fillcap_8
XFILLER_29_698 VDD VDD VSS VSS gf180mcu_fd_sc_mcu7t5v0__fill_2
XFILLER_83_292 VDD VDD VSS VSS gf180mcu_fd_sc_mcu7t5v0__fillcap_32
XFILLER_45_43 VDD VDD VSS VSS gf180mcu_fd_sc_mcu7t5v0__fillcap_16
XFILLER_71_454 VDD VDD VSS VSS gf180mcu_fd_sc_mcu7t5v0__fillcap_8
XFILLER_24_381 VDD VDD VSS VSS gf180mcu_fd_sc_mcu7t5v0__fillcap_4
XTAP_TAPCELL_ROW_42_836 VDD VSS gf180mcu_fd_sc_mcu7t5v0__filltie
XFILLER_129_228 VDD VDD VSS VSS gf180mcu_fd_sc_mcu7t5v0__fillcap_8
XFILLER_61_64 VDD VDD VSS VSS gf180mcu_fd_sc_mcu7t5v0__fillcap_4
XTAP_TAPCELL_ROW_61_1079 VDD VSS gf180mcu_fd_sc_mcu7t5v0__filltie
XTAP_TAPCELL_ROW_117_1813 VDD VSS gf180mcu_fd_sc_mcu7t5v0__filltie
XTAP_TAPCELL_ROW_117_1802 VDD VSS gf180mcu_fd_sc_mcu7t5v0__filltie
XFILLER_8_558 VDD VDD VSS VSS gf180mcu_fd_sc_mcu7t5v0__fillcap_32
XTAP_TAPCELL_ROW_22_571 VDD VSS gf180mcu_fd_sc_mcu7t5v0__filltie
XFILLER_6_37 VDD VDD VSS VSS gf180mcu_fd_sc_mcu7t5v0__fillcap_16
XFILLER_120_172 VDD VDD VSS VSS gf180mcu_fd_sc_mcu7t5v0__fill_2
X_2050_ _2008_/Z _2050_/A2 _2050_/B _4138_/D VDD VDD VSS VSS gf180mcu_fd_sc_mcu7t5v0__oai21_4
XTAP_TAPCELL_ROW_128_1953 VDD VSS gf180mcu_fd_sc_mcu7t5v0__filltie
XFILLER_19_142 VDD VDD VSS VSS gf180mcu_fd_sc_mcu7t5v0__fillcap_64
XFILLER_35_613 VDD VDD VSS VSS gf180mcu_fd_sc_mcu7t5v0__fill_1
XFILLER_34_101 VDD VDD VSS VSS gf180mcu_fd_sc_mcu7t5v0__fillcap_4
XFILLER_34_145 VDD VDD VSS VSS gf180mcu_fd_sc_mcu7t5v0__fill_1
XFILLER_62_454 VDD VDD VSS VSS gf180mcu_fd_sc_mcu7t5v0__fill_1
X_2952_ _4042_/Q _3922_/Q _2972_/S _3922_/D VDD VDD VSS VSS gf180mcu_fd_sc_mcu7t5v0__mux2_2
X_1903_ _3893_/Q _2891_/A1 VDD VDD VSS VSS gf180mcu_fd_sc_mcu7t5v0__clkinv_1
X_2883_ _1892_/B _2900_/S _2883_/B _3889_/D VDD VDD VSS VSS gf180mcu_fd_sc_mcu7t5v0__oai21_1
XTAP_TAPCELL_ROW_79_1307 VDD VSS gf180mcu_fd_sc_mcu7t5v0__filltie
XTAP_TAPCELL_ROW_79_1318 VDD VSS gf180mcu_fd_sc_mcu7t5v0__filltie
XFILLER_116_445 VDD VDD VSS VSS gf180mcu_fd_sc_mcu7t5v0__fillcap_8
X_3504_ _4111_/Q _3504_/A2 _4111_/D VDD VDD VSS VSS gf180mcu_fd_sc_mcu7t5v0__xor2_1
XFILLER_104_629 VDD VDD VSS VSS gf180mcu_fd_sc_mcu7t5v0__fill_2
X_3435_ _3430_/Z _3435_/A2 _3449_/C _3435_/C _3443_/B VDD VDD VSS VSS gf180mcu_fd_sc_mcu7t5v0__oai211_1
XFILLER_106_27 VDD VDD VSS VSS gf180mcu_fd_sc_mcu7t5v0__fillcap_8
XFILLER_98_863 VDD VDD VSS VSS gf180mcu_fd_sc_mcu7t5v0__fillcap_8
XFILLER_97_340 VDD VDD VSS VSS gf180mcu_fd_sc_mcu7t5v0__fillcap_8
X_3366_ _3335_/B _3366_/A2 _3366_/B _3368_/A2 VDD VDD VSS VSS gf180mcu_fd_sc_mcu7t5v0__aoi21_1
XFILLER_100_813 VDD VDD VSS VSS gf180mcu_fd_sc_mcu7t5v0__fill_1
XFILLER_97_395 VDD VDD VSS VSS gf180mcu_fd_sc_mcu7t5v0__fill_1
X_3297_ place82/Z _4161_/Q _4157_/D _4067_/D VDD VDD VSS VSS gf180mcu_fd_sc_mcu7t5v0__mux2_2
X_2317_ _3643_/Q _4073_/Q _2319_/S _3643_/D VDD VDD VSS VSS gf180mcu_fd_sc_mcu7t5v0__mux2_2
X_2248_ _3951_/Q place63/Z place67/Z _3976_/Q _3919_/Q place72/Z _2249_/I VDD VDD
+ VSS VSS gf180mcu_fd_sc_mcu7t5v0__aoi222_1
XFILLER_85_557 VDD VDD VSS VSS gf180mcu_fd_sc_mcu7t5v0__fill_2
XFILLER_38_473 VDD VDD VSS VSS gf180mcu_fd_sc_mcu7t5v0__fillcap_8
XTAP_TAPCELL_ROW_0_277 VDD VSS gf180mcu_fd_sc_mcu7t5v0__filltie
XTAP_TAPCELL_ROW_0_266 VDD VSS gf180mcu_fd_sc_mcu7t5v0__filltie
XTAP_TAPCELL_ROW_0_288 VDD VSS gf180mcu_fd_sc_mcu7t5v0__filltie
XTAP_TAPCELL_ROW_101_1603 VDD VSS gf180mcu_fd_sc_mcu7t5v0__filltie
XFILLER_53_487 VDD VDD VSS VSS gf180mcu_fd_sc_mcu7t5v0__fill_2
XFILLER_107_412 VDD VDD VSS VSS gf180mcu_fd_sc_mcu7t5v0__fillcap_8
XFILLER_5_539 VDD VDD VSS VSS gf180mcu_fd_sc_mcu7t5v0__fillcap_16
XFILLER_122_437 VDD VDD VSS VSS gf180mcu_fd_sc_mcu7t5v0__fillcap_16
XTAP_TAPCELL_ROW_112_1743 VDD VSS gf180mcu_fd_sc_mcu7t5v0__filltie
XTAP_TAPCELL_ROW_8_388 VDD VSS gf180mcu_fd_sc_mcu7t5v0__filltie
Xinput101 hold198/Z _3086_/I1 VDD VDD VSS VSS gf180mcu_fd_sc_mcu7t5v0__dlyb_1
XFILLER_130_481 VDD VDD VSS VSS gf180mcu_fd_sc_mcu7t5v0__fillcap_32
Xinput123 hold229/Z _3142_/I1 VDD VDD VSS VSS gf180mcu_fd_sc_mcu7t5v0__dlyb_1
Xinput112 hold207/Z _3121_/I1 VDD VDD VSS VSS gf180mcu_fd_sc_mcu7t5v0__dlyb_1
Xinput134 hold190/Z _3102_/I1 VDD VDD VSS VSS gf180mcu_fd_sc_mcu7t5v0__dlyb_1
XFILLER_16_123 VDD VDD VSS VSS gf180mcu_fd_sc_mcu7t5v0__fillcap_8
XPHY_EDGE_ROW_113_Right_113 VDD VSS gf180mcu_fd_sc_mcu7t5v0__endcap
XTAP_TAPCELL_ROW_27_641 VDD VSS gf180mcu_fd_sc_mcu7t5v0__filltie
XTAP_TAPCELL_ROW_63_1108 VDD VSS gf180mcu_fd_sc_mcu7t5v0__filltie
XFILLER_16_189 VDD VDD VSS VSS gf180mcu_fd_sc_mcu7t5v0__fill_2
XFILLER_72_52 VDD VDD VSS VSS gf180mcu_fd_sc_mcu7t5v0__fillcap_32
XTAP_TAPCELL_ROW_123_1883 VDD VSS gf180mcu_fd_sc_mcu7t5v0__filltie
XFILLER_99_627 VDD VDD VSS VSS gf180mcu_fd_sc_mcu7t5v0__fill_2
XFILLER_113_426 VDD VDD VSS VSS gf180mcu_fd_sc_mcu7t5v0__fill_2
XTAP_TAPCELL_ROW_74_1248 VDD VSS gf180mcu_fd_sc_mcu7t5v0__filltie
XFILLER_4_583 VDD VDD VSS VSS gf180mcu_fd_sc_mcu7t5v0__fillcap_4
XFILLER_79_384 VDD VDD VSS VSS gf180mcu_fd_sc_mcu7t5v0__fillcap_16
XFILLER_121_492 VDD VDD VSS VSS gf180mcu_fd_sc_mcu7t5v0__fillcap_32
X_2102_ _3629_/Q _3685_/Q _3693_/Q _3701_/Q place79/Z place78/Z _2102_/Z VDD VDD VSS
+ VSS gf180mcu_fd_sc_mcu7t5v0__mux4_1
XFILLER_94_387 VDD VDD VSS VSS gf180mcu_fd_sc_mcu7t5v0__fillcap_16
XFILLER_82_527 VDD VDD VSS VSS gf180mcu_fd_sc_mcu7t5v0__fillcap_32
X_2033_ place52/Z _2033_/A2 _2034_/B VDD VDD VSS VSS gf180mcu_fd_sc_mcu7t5v0__nand2_1
XPHY_EDGE_ROW_6_Left_139 VDD VSS gf180mcu_fd_sc_mcu7t5v0__endcap
XFILLER_36_933 VDD VDD VSS VSS gf180mcu_fd_sc_mcu7t5v0__fill_1
XFILLER_90_593 VDD VDD VSS VSS gf180mcu_fd_sc_mcu7t5v0__fill_2
XTAP_TAPCELL_ROW_85_1388 VDD VSS gf180mcu_fd_sc_mcu7t5v0__filltie
XFILLER_22_104 VDD VDD VSS VSS gf180mcu_fd_sc_mcu7t5v0__fill_1
X_3984_ _3984_/D input92/Z _4129_/CLK _3984_/Q VDD VDD VSS VSS gf180mcu_fd_sc_mcu7t5v0__dffrnq_1
XFILLER_50_457 VDD VDD VSS VSS gf180mcu_fd_sc_mcu7t5v0__fillcap_64
X_2935_ _4034_/Q _3914_/Q _2972_/S _3914_/D VDD VDD VSS VSS gf180mcu_fd_sc_mcu7t5v0__mux2_2
XFILLER_129_570 VDD VDD VSS VSS gf180mcu_fd_sc_mcu7t5v0__fillcap_4
X_1817_ _4145_/Q _1943_/B2 VDD VDD VSS VSS gf180mcu_fd_sc_mcu7t5v0__clkinv_1
X_2797_ place84/Z _3851_/Q _2799_/S _3851_/D VDD VDD VSS VSS gf180mcu_fd_sc_mcu7t5v0__mux2_2
XFILLER_132_713 VDD VDD VSS VSS gf180mcu_fd_sc_mcu7t5v0__fill_1
XFILLER_117_765 VDD VDD VSS VSS gf180mcu_fd_sc_mcu7t5v0__fillcap_4
XFILLER_132_735 VDD VDD VSS VSS gf180mcu_fd_sc_mcu7t5v0__fillcap_8
XFILLER_131_212 VDD VDD VSS VSS gf180mcu_fd_sc_mcu7t5v0__fillcap_64
XFILLER_89_137 VDD VDD VSS VSS gf180mcu_fd_sc_mcu7t5v0__fill_2
X_3418_ _4148_/Q _4107_/Q _4108_/Q _3417_/Z _3418_/Z VDD VDD VSS VSS gf180mcu_fd_sc_mcu7t5v0__and4_1
X_3349_ _3349_/A1 _3349_/A2 _3349_/B1 _3347_/B _3350_/A2 VDD VDD VSS VSS gf180mcu_fd_sc_mcu7t5v0__oai22_1
XFILLER_86_877 VDD VDD VSS VSS gf180mcu_fd_sc_mcu7t5v0__fill_2
XTAP_TAPCELL_ROW_5_347 VDD VSS gf180mcu_fd_sc_mcu7t5v0__filltie
XFILLER_58_546 VDD VDD VSS VSS gf180mcu_fd_sc_mcu7t5v0__fill_2
XFILLER_26_34 VDD VDD VSS VSS gf180mcu_fd_sc_mcu7t5v0__fill_1
XTAP_TAPCELL_ROW_24_600 VDD VSS gf180mcu_fd_sc_mcu7t5v0__filltie
XTAP_TAPCELL_ROW_52_964 VDD VSS gf180mcu_fd_sc_mcu7t5v0__filltie
XFILLER_10_833 VDD VDD VSS VSS gf180mcu_fd_sc_mcu7t5v0__fill_1
XFILLER_127_518 VDD VDD VSS VSS gf180mcu_fd_sc_mcu7t5v0__fill_1
XFILLER_10_877 VDD VDD VSS VSS gf180mcu_fd_sc_mcu7t5v0__fillcap_32
XFILLER_6_804 VDD VDD VSS VSS gf180mcu_fd_sc_mcu7t5v0__fill_1
XFILLER_108_732 VDD VDD VSS VSS gf180mcu_fd_sc_mcu7t5v0__fill_2
XFILLER_5_336 VDD VDD VSS VSS gf180mcu_fd_sc_mcu7t5v0__fillcap_8
XFILLER_5_314 VDD VDD VSS VSS gf180mcu_fd_sc_mcu7t5v0__fillcap_4
XFILLER_123_702 VDD VDD VSS VSS gf180mcu_fd_sc_mcu7t5v0__fillcap_16
XFILLER_123_735 VDD VDD VSS VSS gf180mcu_fd_sc_mcu7t5v0__fillcap_32
XFILLER_122_278 VDD VDD VSS VSS gf180mcu_fd_sc_mcu7t5v0__fill_2
XFILLER_89_693 VDD VDD VSS VSS gf180mcu_fd_sc_mcu7t5v0__fillcap_4
XFILLER_131_790 VDD VDD VSS VSS gf180mcu_fd_sc_mcu7t5v0__fill_1
XFILLER_103_492 VDD VDD VSS VSS gf180mcu_fd_sc_mcu7t5v0__fillcap_64
XFILLER_1_597 VDD VDD VSS VSS gf180mcu_fd_sc_mcu7t5v0__fillcap_32
XFILLER_92_803 VDD VDD VSS VSS gf180mcu_fd_sc_mcu7t5v0__fill_2
XFILLER_64_505 VDD VDD VSS VSS gf180mcu_fd_sc_mcu7t5v0__fillcap_4
XTAP_TAPCELL_ROW_125_1912 VDD VSS gf180mcu_fd_sc_mcu7t5v0__filltie
XFILLER_76_387 VDD VDD VSS VSS gf180mcu_fd_sc_mcu7t5v0__fillcap_8
XFILLER_18_933 VDD VDD VSS VSS gf180mcu_fd_sc_mcu7t5v0__fill_1
XFILLER_33_903 VDD VDD VSS VSS gf180mcu_fd_sc_mcu7t5v0__fillcap_4
XFILLER_45_752 VDD VDD VSS VSS gf180mcu_fd_sc_mcu7t5v0__fill_2
XFILLER_32_457 VDD VDD VSS VSS gf180mcu_fd_sc_mcu7t5v0__fillcap_64
XFILLER_60_799 VDD VDD VSS VSS gf180mcu_fd_sc_mcu7t5v0__fillcap_4
X_2720_ _3816_/Q place87/Z _2728_/S _3816_/D VDD VDD VSS VSS gf180mcu_fd_sc_mcu7t5v0__mux2_2
X_2582_ _4120_/Q _4121_/Q _2581_/Z place47/I VDD VDD VSS VSS gf180mcu_fd_sc_mcu7t5v0__nor3_1
XFILLER_126_573 VDD VDD VSS VSS gf180mcu_fd_sc_mcu7t5v0__fillcap_4
XFILLER_99_468 VDD VDD VSS VSS gf180mcu_fd_sc_mcu7t5v0__fillcap_16
XFILLER_86_107 VDD VDD VSS VSS gf180mcu_fd_sc_mcu7t5v0__fill_2
XTAP_TAPCELL_ROW_87_1417 VDD VSS gf180mcu_fd_sc_mcu7t5v0__filltie
XTAP_TAPCELL_ROW_2_306 VDD VSS gf180mcu_fd_sc_mcu7t5v0__filltie
XTAP_TAPCELL_ROW_2_317 VDD VSS gf180mcu_fd_sc_mcu7t5v0__filltie
XFILLER_68_877 VDD VDD VSS VSS gf180mcu_fd_sc_mcu7t5v0__fillcap_16
XFILLER_95_696 VDD VDD VSS VSS gf180mcu_fd_sc_mcu7t5v0__fillcap_4
XFILLER_94_173 VDD VDD VSS VSS gf180mcu_fd_sc_mcu7t5v0__fill_2
X_3065_ _3065_/A1 _3065_/A2 _3065_/B _3066_/A2 VDD VDD VSS VSS gf180mcu_fd_sc_mcu7t5v0__aoi21_1
X_2016_ place52/Z _2016_/A2 _2017_/B VDD VDD VSS VSS gf180mcu_fd_sc_mcu7t5v0__nand2_1
XFILLER_82_357 VDD VDD VSS VSS gf180mcu_fd_sc_mcu7t5v0__fill_1
XFILLER_51_722 VDD VDD VSS VSS gf180mcu_fd_sc_mcu7t5v0__fill_1
X_3967_ _3967_/D _2279_/I _4098_/CLK _3967_/Q VDD VDD VSS VSS gf180mcu_fd_sc_mcu7t5v0__dffrnq_1
XFILLER_10_107 VDD VDD VSS VSS gf180mcu_fd_sc_mcu7t5v0__fillcap_16
X_2918_ place85/Z _3906_/Q _2972_/S _3906_/D VDD VDD VSS VSS gf180mcu_fd_sc_mcu7t5v0__mux2_2
X_3898_ _3898_/D _4157_/RN _3946_/CLK _3898_/Q VDD VDD VSS VSS gf180mcu_fd_sc_mcu7t5v0__dffrnq_1
Xclkbuf_leaf_30_clk clkload6/I _3733_/CLK VDD VDD VSS VSS gf180mcu_fd_sc_mcu7t5v0__clkbuf_8
XFILLER_128_14 VDD VDD VSS VSS gf180mcu_fd_sc_mcu7t5v0__fillcap_4
XTAP_TAPCELL_ROW_98_1557 VDD VSS gf180mcu_fd_sc_mcu7t5v0__filltie
XFILLER_12_69 VDD VDD VSS VSS gf180mcu_fd_sc_mcu7t5v0__fillcap_16
XFILLER_117_562 VDD VDD VSS VSS gf180mcu_fd_sc_mcu7t5v0__fillcap_64
XFILLER_105_702 VDD VDD VSS VSS gf180mcu_fd_sc_mcu7t5v0__fillcap_8
XFILLER_2_317 VDD VDD VSS VSS gf180mcu_fd_sc_mcu7t5v0__fillcap_4
Xhold196 s_axi_wdata[1] hold196/Z VDD VDD VSS VSS gf180mcu_fd_sc_mcu7t5v0__dlyc_1
XFILLER_58_321 VDD VDD VSS VSS gf180mcu_fd_sc_mcu7t5v0__fill_2
XFILLER_100_451 VDD VDD VSS VSS gf180mcu_fd_sc_mcu7t5v0__fillcap_4
XFILLER_86_663 VDD VDD VSS VSS gf180mcu_fd_sc_mcu7t5v0__fill_2
XFILLER_73_302 VDD VDD VSS VSS gf180mcu_fd_sc_mcu7t5v0__fill_2
XFILLER_73_324 VDD VDD VSS VSS gf180mcu_fd_sc_mcu7t5v0__fillcap_16
XFILLER_46_527 VDD VDD VSS VSS gf180mcu_fd_sc_mcu7t5v0__fillcap_64
XFILLER_58_387 VDD VDD VSS VSS gf180mcu_fd_sc_mcu7t5v0__fillcap_32
XTAP_TAPCELL_ROW_107_1675 VDD VSS gf180mcu_fd_sc_mcu7t5v0__filltie
XFILLER_82_891 VDD VDD VSS VSS gf180mcu_fd_sc_mcu7t5v0__fill_1
XFILLER_54_593 VDD VDD VSS VSS gf180mcu_fd_sc_mcu7t5v0__fill_2
XTAP_TAPCELL_ROW_120_1842 VDD VSS gf180mcu_fd_sc_mcu7t5v0__filltie
Xclkbuf_leaf_21_clk clkload5/I _4092_/CLK VDD VDD VSS VSS gf180mcu_fd_sc_mcu7t5v0__clkbuf_8
XFILLER_10_663 VDD VDD VSS VSS gf180mcu_fd_sc_mcu7t5v0__fill_2
XFILLER_6_601 VDD VDD VSS VSS gf180mcu_fd_sc_mcu7t5v0__fill_1
XFILLER_10_674 VDD VDD VSS VSS gf180mcu_fd_sc_mcu7t5v0__fillcap_4
XFILLER_6_667 VDD VDD VSS VSS gf180mcu_fd_sc_mcu7t5v0__fillcap_16
XFILLER_5_133 VDD VDD VSS VSS gf180mcu_fd_sc_mcu7t5v0__fillcap_4
XFILLER_97_906 VDD VDD VSS VSS gf180mcu_fd_sc_mcu7t5v0__fillcap_4
XTAP_TAPCELL_ROW_71_1207 VDD VSS gf180mcu_fd_sc_mcu7t5v0__filltie
XTAP_TAPCELL_ROW_131_1993 VDD VSS gf180mcu_fd_sc_mcu7t5v0__filltie
XFILLER_97_928 VDD VDD VSS VSS gf180mcu_fd_sc_mcu7t5v0__fillcap_4
XFILLER_96_427 VDD VDD VSS VSS gf180mcu_fd_sc_mcu7t5v0__fillcap_16
XFILLER_68_107 VDD VDD VSS VSS gf180mcu_fd_sc_mcu7t5v0__fillcap_16
XFILLER_65_836 VDD VDD VSS VSS gf180mcu_fd_sc_mcu7t5v0__fillcap_4
XFILLER_92_655 VDD VDD VSS VSS gf180mcu_fd_sc_mcu7t5v0__fill_2
XTAP_TAPCELL_ROW_35_739 VDD VSS gf180mcu_fd_sc_mcu7t5v0__filltie
XPHY_EDGE_ROW_96_Left_229 VDD VSS gf180mcu_fd_sc_mcu7t5v0__endcap
XFILLER_91_198 VDD VDD VSS VSS gf180mcu_fd_sc_mcu7t5v0__fillcap_8
XTAP_TAPCELL_ROW_82_1347 VDD VSS gf180mcu_fd_sc_mcu7t5v0__filltie
XTAP_TAPCELL_ROW_82_1358 VDD VSS gf180mcu_fd_sc_mcu7t5v0__filltie
X_3821_ _3821_/D _3866_/CLK _3821_/Q VDD VDD VSS VSS gf180mcu_fd_sc_mcu7t5v0__dffq_1
XFILLER_21_906 VDD VDD VSS VSS gf180mcu_fd_sc_mcu7t5v0__fillcap_4
XFILLER_21_928 VDD VDD VSS VSS gf180mcu_fd_sc_mcu7t5v0__fillcap_4
XFILLER_33_766 VDD VDD VSS VSS gf180mcu_fd_sc_mcu7t5v0__fillcap_4
XFILLER_60_563 VDD VDD VSS VSS gf180mcu_fd_sc_mcu7t5v0__fill_1
XTAP_TAPCELL_ROW_15_485 VDD VSS gf180mcu_fd_sc_mcu7t5v0__filltie
Xclkbuf_leaf_12_clk clkload1/I _4136_/CLK VDD VDD VSS VSS gf180mcu_fd_sc_mcu7t5v0__clkbuf_8
X_3752_ _3752_/D _4114_/CLK _3752_/Q VDD VDD VSS VSS gf180mcu_fd_sc_mcu7t5v0__dffq_1
X_3683_ _3683_/D _4166_/CLK _3683_/Q VDD VDD VSS VSS gf180mcu_fd_sc_mcu7t5v0__dffq_1
X_2634_ place85/Z _3778_/Q _2638_/S _3778_/D VDD VDD VSS VSS gf180mcu_fd_sc_mcu7t5v0__mux2_2
XFILLER_126_381 VDD VDD VSS VSS gf180mcu_fd_sc_mcu7t5v0__fillcap_4
XFILLER_99_276 VDD VDD VSS VSS gf180mcu_fd_sc_mcu7t5v0__fillcap_4
XTAP_TAPCELL_ROW_93_1498 VDD VSS gf180mcu_fd_sc_mcu7t5v0__filltie
X_4166_ _4166_/D input92/Z _4166_/CLK _4166_/Q VDD VDD VSS VSS gf180mcu_fd_sc_mcu7t5v0__dffrnq_1
X_3117_ _3999_/Q _3117_/I1 _3160_/S _3999_/D VDD VDD VSS VSS gf180mcu_fd_sc_mcu7t5v0__mux2_2
XFILLER_28_527 VDD VDD VSS VSS gf180mcu_fd_sc_mcu7t5v0__fillcap_8
XFILLER_56_836 VDD VDD VSS VSS gf180mcu_fd_sc_mcu7t5v0__fillcap_32
X_4097_ _4097_/D _2279_/I _4098_/CLK _4097_/Q VDD VDD VSS VSS gf180mcu_fd_sc_mcu7t5v0__dffrnq_1
X_3048_ _4046_/Q _3966_/Q _3081_/S _3966_/D VDD VDD VSS VSS gf180mcu_fd_sc_mcu7t5v0__mux2_2
XFILLER_83_699 VDD VDD VSS VSS gf180mcu_fd_sc_mcu7t5v0__fill_1
XFILLER_71_839 VDD VDD VSS VSS gf180mcu_fd_sc_mcu7t5v0__fill_1
XFILLER_130_37 VDD VDD VSS VSS gf180mcu_fd_sc_mcu7t5v0__fillcap_64
XFILLER_36_582 VDD VDD VSS VSS gf180mcu_fd_sc_mcu7t5v0__fillcap_4
XFILLER_24_766 VDD VDD VSS VSS gf180mcu_fd_sc_mcu7t5v0__fill_2
XFILLER_23_276 VDD VDD VSS VSS gf180mcu_fd_sc_mcu7t5v0__fillcap_4
XFILLER_24_799 VDD VDD VSS VSS gf180mcu_fd_sc_mcu7t5v0__fillcap_4
XFILLER_11_449 VDD VDD VSS VSS gf180mcu_fd_sc_mcu7t5v0__fillcap_32
XFILLER_128_6 VDD VDD VSS VSS gf180mcu_fd_sc_mcu7t5v0__fillcap_8
XFILLER_109_337 VDD VDD VSS VSS gf180mcu_fd_sc_mcu7t5v0__fillcap_8
XFILLER_118_893 VDD VDD VSS VSS gf180mcu_fd_sc_mcu7t5v0__fill_1
XFILLER_79_906 VDD VDD VSS VSS gf180mcu_fd_sc_mcu7t5v0__fillcap_4
XFILLER_79_928 VDD VDD VSS VSS gf180mcu_fd_sc_mcu7t5v0__fillcap_4
XTAP_TAPCELL_ROW_109_1704 VDD VSS gf180mcu_fd_sc_mcu7t5v0__filltie
XFILLER_93_419 VDD VDD VSS VSS gf180mcu_fd_sc_mcu7t5v0__fill_1
XFILLER_47_836 VDD VDD VSS VSS gf180mcu_fd_sc_mcu7t5v0__fillcap_4
XFILLER_58_173 VDD VDD VSS VSS gf180mcu_fd_sc_mcu7t5v0__fill_2
XFILLER_59_696 VDD VDD VSS VSS gf180mcu_fd_sc_mcu7t5v0__fillcap_4
XFILLER_100_281 VDD VDD VSS VSS gf180mcu_fd_sc_mcu7t5v0__fillcap_4
XFILLER_74_677 VDD VDD VSS VSS gf180mcu_fd_sc_mcu7t5v0__fill_1
XFILLER_80_52 VDD VDD VSS VSS gf180mcu_fd_sc_mcu7t5v0__fillcap_32
XTAP_TAPCELL_ROW_12_444 VDD VSS gf180mcu_fd_sc_mcu7t5v0__filltie
XFILLER_7_932 VDD VDD VSS VSS gf180mcu_fd_sc_mcu7t5v0__fill_2
XFILLER_89_72 VDD VDD VSS VSS gf180mcu_fd_sc_mcu7t5v0__fillcap_16
XFILLER_124_874 VDD VDD VSS VSS gf180mcu_fd_sc_mcu7t5v0__fill_1
XFILLER_69_405 VDD VDD VSS VSS gf180mcu_fd_sc_mcu7t5v0__fillcap_8
X_2281_ _2281_/A1 _3407_/A2 _2300_/A3 _2540_/A1 VDD VDD VSS VSS gf180mcu_fd_sc_mcu7t5v0__nand3_1
XFILLER_69_438 VDD VDD VSS VSS gf180mcu_fd_sc_mcu7t5v0__fillcap_8
X_4020_ _4020_/D input92/Z _4130_/CLK _4020_/Q VDD VDD VSS VSS gf180mcu_fd_sc_mcu7t5v0__dffrnq_1
XFILLER_1_180 VDD VDD VSS VSS gf180mcu_fd_sc_mcu7t5v0__fill_1
Xclkbuf_leaf_1_clk clkbuf_leaf_5_clk/I clkload8/I VDD VDD VSS VSS gf180mcu_fd_sc_mcu7t5v0__clkbuf_8
XFILLER_93_931 VDD VDD VSS VSS gf180mcu_fd_sc_mcu7t5v0__fill_2
XFILLER_37_346 VDD VDD VSS VSS gf180mcu_fd_sc_mcu7t5v0__fillcap_4
XFILLER_64_154 VDD VDD VSS VSS gf180mcu_fd_sc_mcu7t5v0__fillcap_16
XFILLER_61_894 VDD VDD VSS VSS gf180mcu_fd_sc_mcu7t5v0__fill_1
X_1996_ _1996_/I0 _4109_/Q _3903_/Q _4159_/D VDD VDD VSS VSS gf180mcu_fd_sc_mcu7t5v0__mux2_2
XFILLER_21_769 VDD VDD VSS VSS gf180mcu_fd_sc_mcu7t5v0__fill_1
X_3804_ _3804_/D clkload9/I _3804_/Q VDD VDD VSS VSS gf180mcu_fd_sc_mcu7t5v0__dffq_1
XFILLER_118_101 VDD VDD VSS VSS gf180mcu_fd_sc_mcu7t5v0__fillcap_4
X_3735_ _3735_/D _3755_/CLK _3735_/Q VDD VDD VSS VSS gf180mcu_fd_sc_mcu7t5v0__dffq_1
XTAP_TAPCELL_ROW_95_1527 VDD VSS gf180mcu_fd_sc_mcu7t5v0__filltie
XTAP_TAPCELL_ROW_95_1516 VDD VSS gf180mcu_fd_sc_mcu7t5v0__filltie
Xclkload50 _4128_/CLK clkload50/Z VDD VDD VSS VSS gf180mcu_fd_sc_mcu7t5v0__clkbuf_2
XFILLER_106_307 VDD VDD VSS VSS gf180mcu_fd_sc_mcu7t5v0__fillcap_8
X_3666_ _3666_/D _4094_/CLK _3666_/Q VDD VDD VSS VSS gf180mcu_fd_sc_mcu7t5v0__dffq_1
X_2617_ place84/Z _3771_/Q _2619_/S _3771_/D VDD VDD VSS VSS gf180mcu_fd_sc_mcu7t5v0__mux2_2
X_3597_ _3876_/Q _3884_/Q _3772_/Q _3780_/Q place76/Z place75/Z _3597_/Z VDD VDD VSS
+ VSS gf180mcu_fd_sc_mcu7t5v0__mux4_1
XFILLER_115_863 VDD VDD VSS VSS gf180mcu_fd_sc_mcu7t5v0__fillcap_32
X_2548_ _3744_/Q place81/Z _2556_/S _3744_/D VDD VDD VSS VSS gf180mcu_fd_sc_mcu7t5v0__mux2_2
XFILLER_125_48 VDD VDD VSS VSS gf180mcu_fd_sc_mcu7t5v0__fillcap_16
XFILLER_88_769 VDD VDD VSS VSS gf180mcu_fd_sc_mcu7t5v0__fillcap_16
XFILLER_130_877 VDD VDD VSS VSS gf180mcu_fd_sc_mcu7t5v0__fillcap_8
XFILLER_102_579 VDD VDD VSS VSS gf180mcu_fd_sc_mcu7t5v0__fill_2
XFILLER_75_408 VDD VDD VSS VSS gf180mcu_fd_sc_mcu7t5v0__fillcap_8
X_2479_ _3713_/Q _4071_/Q _2485_/S _3713_/D VDD VDD VSS VSS gf180mcu_fd_sc_mcu7t5v0__mux2_2
XFILLER_84_920 VDD VDD VSS VSS gf180mcu_fd_sc_mcu7t5v0__fillcap_8
XFILLER_29_836 VDD VDD VSS VSS gf180mcu_fd_sc_mcu7t5v0__fillcap_4
X_4149_ _4149_/D _4157_/RN _4156_/CLK _4149_/Q VDD VDD VSS VSS gf180mcu_fd_sc_mcu7t5v0__dffrnq_1
XFILLER_71_625 VDD VDD VSS VSS gf180mcu_fd_sc_mcu7t5v0__fillcap_4
XFILLER_43_305 VDD VDD VSS VSS gf180mcu_fd_sc_mcu7t5v0__fillcap_4
XTAP_TAPCELL_ROW_104_1634 VDD VSS gf180mcu_fd_sc_mcu7t5v0__filltie
XFILLER_24_563 VDD VDD VSS VSS gf180mcu_fd_sc_mcu7t5v0__fill_1
XFILLER_34_34 VDD VDD VSS VSS gf180mcu_fd_sc_mcu7t5v0__fill_1
XFILLER_12_725 VDD VDD VSS VSS gf180mcu_fd_sc_mcu7t5v0__fillcap_8
XFILLER_11_268 VDD VDD VSS VSS gf180mcu_fd_sc_mcu7t5v0__fillcap_8
XFILLER_7_206 VDD VDD VSS VSS gf180mcu_fd_sc_mcu7t5v0__fillcap_4
Xclkload0 clkload0/I clkload0/ZN VDD VDD VSS VSS gf180mcu_fd_sc_mcu7t5v0__inv_4
XFILLER_109_134 VDD VDD VSS VSS gf180mcu_fd_sc_mcu7t5v0__fillcap_4
XFILLER_124_115 VDD VDD VSS VSS gf180mcu_fd_sc_mcu7t5v0__fillcap_4
XFILLER_50_99 VDD VDD VSS VSS gf180mcu_fd_sc_mcu7t5v0__fillcap_4
XTAP_TAPCELL_ROW_115_1785 VDD VSS gf180mcu_fd_sc_mcu7t5v0__filltie
XFILLER_106_874 VDD VDD VSS VSS gf180mcu_fd_sc_mcu7t5v0__fill_1
XFILLER_1_2 VDD VDD VSS VSS gf180mcu_fd_sc_mcu7t5v0__fillcap_8
XFILLER_78_235 VDD VDD VSS VSS gf180mcu_fd_sc_mcu7t5v0__fillcap_8
XFILLER_3_489 VDD VDD VSS VSS gf180mcu_fd_sc_mcu7t5v0__fill_1
XFILLER_79_769 VDD VDD VSS VSS gf180mcu_fd_sc_mcu7t5v0__fill_1
XFILLER_120_387 VDD VDD VSS VSS gf180mcu_fd_sc_mcu7t5v0__fillcap_16
XTAP_TAPCELL_ROW_17_503 VDD VSS gf180mcu_fd_sc_mcu7t5v0__filltie
XFILLER_62_658 VDD VDD VSS VSS gf180mcu_fd_sc_mcu7t5v0__fillcap_4
XTAP_TAPCELL_ROW_66_1139 VDD VSS gf180mcu_fd_sc_mcu7t5v0__filltie
XFILLER_43_850 VDD VDD VSS VSS gf180mcu_fd_sc_mcu7t5v0__fill_1
XTAP_TAPCELL_ROW_45_867 VDD VSS gf180mcu_fd_sc_mcu7t5v0__filltie
XFILLER_30_522 VDD VDD VSS VSS gf180mcu_fd_sc_mcu7t5v0__fill_2
XFILLER_43_894 VDD VDD VSS VSS gf180mcu_fd_sc_mcu7t5v0__fill_1
X_1850_ _3891_/Q _3889_/Q _3890_/Q _1913_/A1 VDD VDD VSS VSS gf180mcu_fd_sc_mcu7t5v0__nor3_1
XFILLER_30_577 VDD VDD VSS VSS gf180mcu_fd_sc_mcu7t5v0__fill_1
XFILLER_128_454 VDD VDD VSS VSS gf180mcu_fd_sc_mcu7t5v0__fill_1
X_3520_ _2182_/Z _3520_/A2 _3550_/A2 VDD VDD VSS VSS gf180mcu_fd_sc_mcu7t5v0__nor2_1
XFILLER_131_619 VDD VDD VSS VSS gf180mcu_fd_sc_mcu7t5v0__fillcap_8
X_3382_ _4085_/Q _4086_/Q _3376_/Z _3382_/B _3383_/A2 VDD VDD VSS VSS gf180mcu_fd_sc_mcu7t5v0__oai31_1
X_2402_ _4069_/Q _3679_/Q _2412_/S _3679_/D VDD VDD VSS VSS gf180mcu_fd_sc_mcu7t5v0__mux2_2
XTAP_TAPCELL_ROW_90_1457 VDD VSS gf180mcu_fd_sc_mcu7t5v0__filltie
XFILLER_34_2 VDD VDD VSS VSS gf180mcu_fd_sc_mcu7t5v0__fillcap_32
XFILLER_112_877 VDD VDD VSS VSS gf180mcu_fd_sc_mcu7t5v0__fillcap_32
XFILLER_58_909 VDD VDD VSS VSS gf180mcu_fd_sc_mcu7t5v0__fillcap_16
XPHY_EDGE_ROW_127_Right_127 VDD VSS gf180mcu_fd_sc_mcu7t5v0__endcap
X_2264_ _3927_/Q place72/Z place63/Z _3959_/Q _3967_/Q place67/Z _2265_/I VDD VDD
+ VSS VSS gf180mcu_fd_sc_mcu7t5v0__aoi222_1
XFILLER_111_376 VDD VDD VSS VSS gf180mcu_fd_sc_mcu7t5v0__fill_2
XFILLER_57_419 VDD VDD VSS VSS gf180mcu_fd_sc_mcu7t5v0__fill_1
X_4003_ _4003_/D input92/Z _4036_/CLK _4003_/Q VDD VDD VSS VSS gf180mcu_fd_sc_mcu7t5v0__dffrnq_1
X_2195_ _2112_/I _4078_/Q _4079_/Q _4080_/Q _2196_/C VDD VDD VSS VSS gf180mcu_fd_sc_mcu7t5v0__nor4_1
XFILLER_93_772 VDD VDD VSS VSS gf180mcu_fd_sc_mcu7t5v0__fillcap_64
XFILLER_81_912 VDD VDD VSS VSS gf180mcu_fd_sc_mcu7t5v0__fillcap_16
XFILLER_1_60 VDD VDD VSS VSS gf180mcu_fd_sc_mcu7t5v0__fillcap_8
XFILLER_26_839 VDD VDD VSS VSS gf180mcu_fd_sc_mcu7t5v0__fillcap_4
XFILLER_38_677 VDD VDD VSS VSS gf180mcu_fd_sc_mcu7t5v0__fill_1
XFILLER_25_349 VDD VDD VSS VSS gf180mcu_fd_sc_mcu7t5v0__fill_1
X_1979_ _4088_/Q _3391_/B VDD VDD VSS VSS gf180mcu_fd_sc_mcu7t5v0__clkinv_1
XFILLER_106_104 VDD VDD VSS VSS gf180mcu_fd_sc_mcu7t5v0__fill_1
X_3718_ _3718_/D _3732_/CLK _3718_/Q VDD VDD VSS VSS gf180mcu_fd_sc_mcu7t5v0__dffq_1
XFILLER_20_58 VDD VDD VSS VSS gf180mcu_fd_sc_mcu7t5v0__fillcap_32
X_3649_ _3649_/D _4157_/CLK _3649_/Q VDD VDD VSS VSS gf180mcu_fd_sc_mcu7t5v0__dffq_1
XFILLER_49_909 VDD VDD VSS VSS gf180mcu_fd_sc_mcu7t5v0__fill_1
XFILLER_76_728 VDD VDD VSS VSS gf180mcu_fd_sc_mcu7t5v0__fillcap_4
XFILLER_17_839 VDD VDD VSS VSS gf180mcu_fd_sc_mcu7t5v0__fill_1
XFILLER_28_143 VDD VDD VSS VSS gf180mcu_fd_sc_mcu7t5v0__fill_2
XFILLER_56_452 VDD VDD VSS VSS gf180mcu_fd_sc_mcu7t5v0__fill_2
XFILLER_83_282 VDD VDD VSS VSS gf180mcu_fd_sc_mcu7t5v0__fillcap_4
XFILLER_44_658 VDD VDD VSS VSS gf180mcu_fd_sc_mcu7t5v0__fillcap_4
XFILLER_71_422 VDD VDD VSS VSS gf180mcu_fd_sc_mcu7t5v0__fillcap_32
XFILLER_25_850 VDD VDD VSS VSS gf180mcu_fd_sc_mcu7t5v0__fill_2
XFILLER_71_488 VDD VDD VSS VSS gf180mcu_fd_sc_mcu7t5v0__fill_2
XTAP_TAPCELL_ROW_42_826 VDD VSS gf180mcu_fd_sc_mcu7t5v0__filltie
XTAP_TAPCELL_ROW_42_837 VDD VSS gf180mcu_fd_sc_mcu7t5v0__filltie
XFILLER_129_207 VDD VDD VSS VSS gf180mcu_fd_sc_mcu7t5v0__fill_2
XFILLER_101_72 VDD VDD VSS VSS gf180mcu_fd_sc_mcu7t5v0__fillcap_16
XFILLER_52_691 VDD VDD VSS VSS gf180mcu_fd_sc_mcu7t5v0__fillcap_4
XFILLER_61_10 VDD VDD VSS VSS gf180mcu_fd_sc_mcu7t5v0__fillcap_4
XTAP_TAPCELL_ROW_117_1803 VDD VSS gf180mcu_fd_sc_mcu7t5v0__filltie
XTAP_TAPCELL_ROW_22_572 VDD VSS gf180mcu_fd_sc_mcu7t5v0__filltie
XFILLER_126_925 VDD VDD VSS VSS gf180mcu_fd_sc_mcu7t5v0__fillcap_8
XFILLER_112_107 VDD VDD VSS VSS gf180mcu_fd_sc_mcu7t5v0__fillcap_64
XFILLER_48_931 VDD VDD VSS VSS gf180mcu_fd_sc_mcu7t5v0__fill_2
XTAP_TAPCELL_ROW_128_1954 VDD VSS gf180mcu_fd_sc_mcu7t5v0__filltie
XFILLER_63_912 VDD VDD VSS VSS gf180mcu_fd_sc_mcu7t5v0__fillcap_16
XFILLER_74_271 VDD VDD VSS VSS gf180mcu_fd_sc_mcu7t5v0__fill_2
XFILLER_23_809 VDD VDD VSS VSS gf180mcu_fd_sc_mcu7t5v0__fill_2
X_1902_ _3893_/Q _1901_/C _2058_/A1 _3894_/Q _1908_/A2 VDD VDD VSS VSS gf180mcu_fd_sc_mcu7t5v0__oai31_1
XFILLER_31_842 VDD VDD VSS VSS gf180mcu_fd_sc_mcu7t5v0__fillcap_64
X_2882_ _4025_/Q _2900_/S _2883_/B VDD VDD VSS VSS gf180mcu_fd_sc_mcu7t5v0__nand2_1
XFILLER_30_341 VDD VDD VSS VSS gf180mcu_fd_sc_mcu7t5v0__fill_2
X_1833_ _1824_/Z _1833_/A2 _1833_/B1 _1832_/Z _1949_/A1 VDD VDD VSS VSS gf180mcu_fd_sc_mcu7t5v0__oai22_2
XTAP_TAPCELL_ROW_79_1319 VDD VSS gf180mcu_fd_sc_mcu7t5v0__filltie
XTAP_TAPCELL_ROW_79_1308 VDD VSS gf180mcu_fd_sc_mcu7t5v0__filltie
X_3503_ _4110_/Q _3501_/Z _3503_/B _3504_/A2 VDD VDD VSS VSS gf180mcu_fd_sc_mcu7t5v0__oai21_1
XFILLER_132_928 VDD VDD VSS VSS gf180mcu_fd_sc_mcu7t5v0__fillcap_4
XFILLER_116_457 VDD VDD VSS VSS gf180mcu_fd_sc_mcu7t5v0__fillcap_16
X_3434_ _3485_/B _4104_/Q _3435_/C VDD VDD VSS VSS gf180mcu_fd_sc_mcu7t5v0__nor2_1
XFILLER_131_416 VDD VDD VSS VSS gf180mcu_fd_sc_mcu7t5v0__fillcap_4
X_3365_ _4083_/Q _3365_/A2 _3366_/B VDD VDD VSS VSS gf180mcu_fd_sc_mcu7t5v0__and2_1
XFILLER_85_525 VDD VDD VSS VSS gf180mcu_fd_sc_mcu7t5v0__fillcap_16
X_3296_ _3285_/Z _3294_/Z _3296_/B _4066_/D VDD VDD VSS VSS gf180mcu_fd_sc_mcu7t5v0__aoi21_2
X_2247_ _2247_/I _2247_/ZN VDD VDD VSS VSS gf180mcu_fd_sc_mcu7t5v0__inv_1
XFILLER_54_912 VDD VDD VSS VSS gf180mcu_fd_sc_mcu7t5v0__fillcap_16
XFILLER_81_742 VDD VDD VSS VSS gf180mcu_fd_sc_mcu7t5v0__fillcap_16
XFILLER_65_282 VDD VDD VSS VSS gf180mcu_fd_sc_mcu7t5v0__fillcap_64
XTAP_TAPCELL_ROW_0_278 VDD VSS gf180mcu_fd_sc_mcu7t5v0__filltie
XTAP_TAPCELL_ROW_0_267 VDD VSS gf180mcu_fd_sc_mcu7t5v0__filltie
XFILLER_26_658 VDD VDD VSS VSS gf180mcu_fd_sc_mcu7t5v0__fillcap_4
XFILLER_53_466 VDD VDD VSS VSS gf180mcu_fd_sc_mcu7t5v0__fillcap_4
XTAP_TAPCELL_ROW_101_1604 VDD VSS gf180mcu_fd_sc_mcu7t5v0__filltie
XFILLER_81_797 VDD VDD VSS VSS gf180mcu_fd_sc_mcu7t5v0__fillcap_32
XTAP_TAPCELL_ROW_0_289 VDD VSS gf180mcu_fd_sc_mcu7t5v0__filltie
XFILLER_5_507 VDD VDD VSS VSS gf180mcu_fd_sc_mcu7t5v0__fillcap_32
XFILLER_119_284 VDD VDD VSS VSS gf180mcu_fd_sc_mcu7t5v0__fill_1
XFILLER_123_928 VDD VDD VSS VSS gf180mcu_fd_sc_mcu7t5v0__fillcap_4
XFILLER_1_702 VDD VDD VSS VSS gf180mcu_fd_sc_mcu7t5v0__fillcap_64
XTAP_TAPCELL_ROW_112_1744 VDD VSS gf180mcu_fd_sc_mcu7t5v0__filltie
XFILLER_89_842 VDD VDD VSS VSS gf180mcu_fd_sc_mcu7t5v0__fillcap_16
Xinput102 hold216/Z _3088_/I1 VDD VDD VSS VSS gf180mcu_fd_sc_mcu7t5v0__dlyb_1
Xinput124 hold228/Z _3144_/I1 VDD VDD VSS VSS gf180mcu_fd_sc_mcu7t5v0__dlyb_1
XFILLER_103_696 VDD VDD VSS VSS gf180mcu_fd_sc_mcu7t5v0__fillcap_4
Xinput113 hold225/Z _3123_/I1 VDD VDD VSS VSS gf180mcu_fd_sc_mcu7t5v0__dlyb_1
XTAP_TAPCELL_ROW_8_389 VDD VSS gf180mcu_fd_sc_mcu7t5v0__filltie
Xinput135 hold226/Z _3104_/I1 VDD VDD VSS VSS gf180mcu_fd_sc_mcu7t5v0__dlyb_1
XFILLER_102_173 VDD VDD VSS VSS gf180mcu_fd_sc_mcu7t5v0__fill_2
XFILLER_45_912 VDD VDD VSS VSS gf180mcu_fd_sc_mcu7t5v0__fillcap_16
XFILLER_57_772 VDD VDD VSS VSS gf180mcu_fd_sc_mcu7t5v0__fillcap_64
XFILLER_72_731 VDD VDD VSS VSS gf180mcu_fd_sc_mcu7t5v0__fillcap_4
XPHY_EDGE_ROW_19_Right_19 VDD VSS gf180mcu_fd_sc_mcu7t5v0__endcap
XTAP_TAPCELL_ROW_27_631 VDD VSS gf180mcu_fd_sc_mcu7t5v0__filltie
XTAP_TAPCELL_ROW_27_642 VDD VSS gf180mcu_fd_sc_mcu7t5v0__filltie
XFILLER_44_477 VDD VDD VSS VSS gf180mcu_fd_sc_mcu7t5v0__fill_2
XTAP_TAPCELL_ROW_55_995 VDD VSS gf180mcu_fd_sc_mcu7t5v0__filltie
XTAP_TAPCELL_ROW_63_1109 VDD VSS gf180mcu_fd_sc_mcu7t5v0__filltie
XTAP_TAPCELL_ROW_123_1884 VDD VSS gf180mcu_fd_sc_mcu7t5v0__filltie
XFILLER_13_842 VDD VDD VSS VSS gf180mcu_fd_sc_mcu7t5v0__fill_2
XFILLER_31_138 VDD VDD VSS VSS gf180mcu_fd_sc_mcu7t5v0__fill_2
XFILLER_12_341 VDD VDD VSS VSS gf180mcu_fd_sc_mcu7t5v0__fillcap_4
XFILLER_8_312 VDD VDD VSS VSS gf180mcu_fd_sc_mcu7t5v0__fill_2
XFILLER_40_661 VDD VDD VSS VSS gf180mcu_fd_sc_mcu7t5v0__fillcap_4
Xclkbuf_3_1__f_clk clkbuf_0_clk/Z clkload0/I VDD VDD VSS VSS gf180mcu_fd_sc_mcu7t5v0__clkbuf_16
XFILLER_126_733 VDD VDD VSS VSS gf180mcu_fd_sc_mcu7t5v0__fill_2
XPHY_EDGE_ROW_28_Right_28 VDD VSS gf180mcu_fd_sc_mcu7t5v0__endcap
XFILLER_125_276 VDD VDD VSS VSS gf180mcu_fd_sc_mcu7t5v0__fillcap_4
XTAP_TAPCELL_ROW_74_1249 VDD VSS gf180mcu_fd_sc_mcu7t5v0__filltie
XFILLER_97_72 VDD VDD VSS VSS gf180mcu_fd_sc_mcu7t5v0__fillcap_16
XFILLER_79_352 VDD VDD VSS VSS gf180mcu_fd_sc_mcu7t5v0__fillcap_32
X_3150_ _4015_/Q _3150_/I1 _3160_/S _4015_/D VDD VDD VSS VSS gf180mcu_fd_sc_mcu7t5v0__mux2_2
XFILLER_95_834 VDD VDD VSS VSS gf180mcu_fd_sc_mcu7t5v0__fillcap_4
XFILLER_94_300 VDD VDD VSS VSS gf180mcu_fd_sc_mcu7t5v0__fill_2
X_3081_ _4044_/Q _3981_/Q _3081_/S _3981_/D VDD VDD VSS VSS gf180mcu_fd_sc_mcu7t5v0__mux2_2
X_2101_ _2112_/I _2152_/S input97/Z _2109_/I _3375_/A2 VDD VDD VSS VSS gf180mcu_fd_sc_mcu7t5v0__nor4_4
X_2032_ _2097_/A2 _2097_/A3 _2033_/A2 _2034_/A2 VDD VDD VSS VSS gf180mcu_fd_sc_mcu7t5v0__nand3_2
XFILLER_36_901 VDD VDD VSS VSS gf180mcu_fd_sc_mcu7t5v0__fill_1
XFILLER_35_422 VDD VDD VSS VSS gf180mcu_fd_sc_mcu7t5v0__fillcap_16
XPHY_EDGE_ROW_37_Right_37 VDD VSS gf180mcu_fd_sc_mcu7t5v0__endcap
XFILLER_47_282 VDD VDD VSS VSS gf180mcu_fd_sc_mcu7t5v0__fillcap_32
XFILLER_62_241 VDD VDD VSS VSS gf180mcu_fd_sc_mcu7t5v0__fillcap_4
XTAP_TAPCELL_ROW_85_1389 VDD VSS gf180mcu_fd_sc_mcu7t5v0__filltie
XFILLER_35_488 VDD VDD VSS VSS gf180mcu_fd_sc_mcu7t5v0__fill_2
XFILLER_50_403 VDD VDD VSS VSS gf180mcu_fd_sc_mcu7t5v0__fillcap_4
XFILLER_62_263 VDD VDD VSS VSS gf180mcu_fd_sc_mcu7t5v0__fillcap_8
X_3983_ _3983_/D input92/Z _4129_/CLK _3983_/Q VDD VDD VSS VSS gf180mcu_fd_sc_mcu7t5v0__dffrnq_1
XFILLER_31_672 VDD VDD VSS VSS gf180mcu_fd_sc_mcu7t5v0__fillcap_16
X_2865_ place84/Z _3883_/Q _2867_/S _3883_/D VDD VDD VSS VSS gf180mcu_fd_sc_mcu7t5v0__mux2_2
X_1816_ _4145_/Q _1835_/B _1824_/I0 VDD VDD VSS VSS gf180mcu_fd_sc_mcu7t5v0__nand2_1
XPHY_EDGE_ROW_46_Right_46 VDD VSS gf180mcu_fd_sc_mcu7t5v0__endcap
XFILLER_116_243 VDD VDD VSS VSS gf180mcu_fd_sc_mcu7t5v0__fill_2
XFILLER_105_928 VDD VDD VSS VSS gf180mcu_fd_sc_mcu7t5v0__fillcap_4
XFILLER_132_747 VDD VDD VSS VSS gf180mcu_fd_sc_mcu7t5v0__fill_1
X_3417_ _4105_/Q _4106_/Q _3417_/Z VDD VDD VSS VSS gf180mcu_fd_sc_mcu7t5v0__and2_1
XFILLER_98_661 VDD VDD VSS VSS gf180mcu_fd_sc_mcu7t5v0__fillcap_4
XFILLER_86_801 VDD VDD VSS VSS gf180mcu_fd_sc_mcu7t5v0__fillcap_4
X_3348_ _3253_/Z _3284_/Z _3349_/B1 VDD VDD VSS VSS gf180mcu_fd_sc_mcu7t5v0__nand2_1
XFILLER_86_845 VDD VDD VSS VSS gf180mcu_fd_sc_mcu7t5v0__fill_1
XTAP_TAPCELL_ROW_5_348 VDD VSS gf180mcu_fd_sc_mcu7t5v0__filltie
XFILLER_27_912 VDD VDD VSS VSS gf180mcu_fd_sc_mcu7t5v0__fillcap_16
X_3279_ _3340_/A2 _3280_/A2 _4065_/Q _3280_/B VDD VDD VSS VSS gf180mcu_fd_sc_mcu7t5v0__oai21_1
XFILLER_39_772 VDD VDD VSS VSS gf180mcu_fd_sc_mcu7t5v0__fillcap_16
XFILLER_46_709 VDD VDD VSS VSS gf180mcu_fd_sc_mcu7t5v0__fillcap_16
XPHY_EDGE_ROW_55_Right_55 VDD VSS gf180mcu_fd_sc_mcu7t5v0__endcap
XPHY_EDGE_ROW_116_Left_249 VDD VSS gf180mcu_fd_sc_mcu7t5v0__endcap
XFILLER_39_794 VDD VDD VSS VSS gf180mcu_fd_sc_mcu7t5v0__fill_1
XFILLER_54_753 VDD VDD VSS VSS gf180mcu_fd_sc_mcu7t5v0__fillcap_8
XTAP_TAPCELL_ROW_24_601 VDD VSS gf180mcu_fd_sc_mcu7t5v0__filltie
XFILLER_41_414 VDD VDD VSS VSS gf180mcu_fd_sc_mcu7t5v0__fillcap_4
XFILLER_42_34 VDD VDD VSS VSS gf180mcu_fd_sc_mcu7t5v0__fill_1
XTAP_TAPCELL_ROW_52_965 VDD VSS gf180mcu_fd_sc_mcu7t5v0__filltie
XFILLER_10_823 VDD VDD VSS VSS gf180mcu_fd_sc_mcu7t5v0__fillcap_8
XFILLER_21_171 VDD VDD VSS VSS gf180mcu_fd_sc_mcu7t5v0__fillcap_8
XPHY_EDGE_ROW_64_Right_64 VDD VSS gf180mcu_fd_sc_mcu7t5v0__endcap
XFILLER_127_508 VDD VDD VSS VSS gf180mcu_fd_sc_mcu7t5v0__fillcap_8
XPHY_EDGE_ROW_125_Left_258 VDD VSS gf180mcu_fd_sc_mcu7t5v0__endcap
XFILLER_101_2 VDD VDD VSS VSS gf180mcu_fd_sc_mcu7t5v0__fillcap_8
XFILLER_5_348 VDD VDD VSS VSS gf180mcu_fd_sc_mcu7t5v0__fill_2
XFILLER_107_298 VDD VDD VSS VSS gf180mcu_fd_sc_mcu7t5v0__fill_1
XFILLER_107_265 VDD VDD VSS VSS gf180mcu_fd_sc_mcu7t5v0__fillcap_4
XFILLER_123_769 VDD VDD VSS VSS gf180mcu_fd_sc_mcu7t5v0__fill_1
XFILLER_107_82 VDD VDD VSS VSS gf180mcu_fd_sc_mcu7t5v0__fill_1
XFILLER_95_119 VDD VDD VSS VSS gf180mcu_fd_sc_mcu7t5v0__fillcap_16
XFILLER_88_171 VDD VDD VSS VSS gf180mcu_fd_sc_mcu7t5v0__fillcap_4
XFILLER_76_333 VDD VDD VSS VSS gf180mcu_fd_sc_mcu7t5v0__fillcap_8
XFILLER_76_311 VDD VDD VSS VSS gf180mcu_fd_sc_mcu7t5v0__fillcap_4
XPHY_EDGE_ROW_73_Right_73 VDD VSS gf180mcu_fd_sc_mcu7t5v0__endcap
XFILLER_67_42 VDD VDD VSS VSS gf180mcu_fd_sc_mcu7t5v0__fillcap_16
XTAP_TAPCELL_ROW_125_1913 VDD VSS gf180mcu_fd_sc_mcu7t5v0__filltie
XFILLER_91_314 VDD VDD VSS VSS gf180mcu_fd_sc_mcu7t5v0__fillcap_16
XFILLER_17_422 VDD VDD VSS VSS gf180mcu_fd_sc_mcu7t5v0__fillcap_64
XFILLER_29_282 VDD VDD VSS VSS gf180mcu_fd_sc_mcu7t5v0__fillcap_64
XFILLER_72_594 VDD VDD VSS VSS gf180mcu_fd_sc_mcu7t5v0__fill_1
XFILLER_60_745 VDD VDD VSS VSS gf180mcu_fd_sc_mcu7t5v0__fill_1
XPHY_EDGE_ROW_82_Right_82 VDD VSS gf180mcu_fd_sc_mcu7t5v0__endcap
XFILLER_9_632 VDD VDD VSS VSS gf180mcu_fd_sc_mcu7t5v0__fillcap_32
XFILLER_12_193 VDD VDD VSS VSS gf180mcu_fd_sc_mcu7t5v0__fillcap_16
X_2650_ place87/Z _3784_/Q _2658_/S _3784_/D VDD VDD VSS VSS gf180mcu_fd_sc_mcu7t5v0__mux2_2
XFILLER_9_687 VDD VDD VSS VSS gf180mcu_fd_sc_mcu7t5v0__fillcap_8
X_2581_ _4122_/Q _4123_/Q _2766_/A3 _2581_/Z VDD VDD VSS VSS gf180mcu_fd_sc_mcu7t5v0__or3_4
XFILLER_99_414 VDD VDD VSS VSS gf180mcu_fd_sc_mcu7t5v0__fillcap_4
XFILLER_113_279 VDD VDD VSS VSS gf180mcu_fd_sc_mcu7t5v0__fill_1
X_3202_ _4040_/Q _4008_/Q _4129_/D _4040_/D VDD VDD VSS VSS gf180mcu_fd_sc_mcu7t5v0__mux2_2
XPHY_EDGE_ROW_91_Right_91 VDD VSS gf180mcu_fd_sc_mcu7t5v0__endcap
XFILLER_68_867 VDD VDD VSS VSS gf180mcu_fd_sc_mcu7t5v0__fillcap_8
X_3133_ _4007_/Q _3133_/I1 _3160_/S _4007_/D VDD VDD VSS VSS gf180mcu_fd_sc_mcu7t5v0__mux2_2
XTAP_TAPCELL_ROW_87_1418 VDD VSS gf180mcu_fd_sc_mcu7t5v0__filltie
XTAP_TAPCELL_ROW_2_307 VDD VSS gf180mcu_fd_sc_mcu7t5v0__filltie
XTAP_TAPCELL_ROW_2_318 VDD VSS gf180mcu_fd_sc_mcu7t5v0__filltie
XFILLER_67_344 VDD VDD VSS VSS gf180mcu_fd_sc_mcu7t5v0__fillcap_4
X_3064_ _3459_/A1 _3065_/A1 _3065_/B VDD VDD VSS VSS gf180mcu_fd_sc_mcu7t5v0__nor2_1
X_2015_ _2097_/A2 _2097_/A3 _2016_/A2 _2017_/A2 VDD VDD VSS VSS gf180mcu_fd_sc_mcu7t5v0__nand3_2
XFILLER_82_347 VDD VDD VSS VSS gf180mcu_fd_sc_mcu7t5v0__fillcap_8
XFILLER_36_753 VDD VDD VSS VSS gf180mcu_fd_sc_mcu7t5v0__fillcap_4
XFILLER_23_436 VDD VDD VSS VSS gf180mcu_fd_sc_mcu7t5v0__fill_1
X_3966_ _3966_/D _2279_/I _4125_/CLK _3966_/Q VDD VDD VSS VSS gf180mcu_fd_sc_mcu7t5v0__dffrnq_1
X_3897_ _3897_/D _4157_/RN _3946_/CLK _3897_/Q VDD VDD VSS VSS gf180mcu_fd_sc_mcu7t5v0__dffrnq_1
XTAP_TAPCELL_ROW_98_1558 VDD VSS gf180mcu_fd_sc_mcu7t5v0__filltie
XFILLER_12_37 VDD VDD VSS VSS gf180mcu_fd_sc_mcu7t5v0__fillcap_32
X_2848_ place84/Z _3875_/Q _2850_/S _3875_/D VDD VDD VSS VSS gf180mcu_fd_sc_mcu7t5v0__mux2_2
XFILLER_132_577 VDD VDD VSS VSS gf180mcu_fd_sc_mcu7t5v0__fill_1
Xhold197 s_axi_wdata[25] hold197/Z VDD VDD VSS VSS gf180mcu_fd_sc_mcu7t5v0__dlyc_1
XFILLER_101_931 VDD VDD VSS VSS gf180mcu_fd_sc_mcu7t5v0__fill_2
XTAP_TAPCELL_ROW_107_1676 VDD VSS gf180mcu_fd_sc_mcu7t5v0__filltie
XTAP_TAPCELL_ROW_37_770 VDD VSS gf180mcu_fd_sc_mcu7t5v0__filltie
XFILLER_42_734 VDD VDD VSS VSS gf180mcu_fd_sc_mcu7t5v0__fill_1
XTAP_TAPCELL_ROW_120_1843 VDD VSS gf180mcu_fd_sc_mcu7t5v0__filltie
XFILLER_30_929 VDD VDD VSS VSS gf180mcu_fd_sc_mcu7t5v0__fillcap_4
XFILLER_41_277 VDD VDD VSS VSS gf180mcu_fd_sc_mcu7t5v0__fill_2
XFILLER_128_839 VDD VDD VSS VSS gf180mcu_fd_sc_mcu7t5v0__fill_1
XFILLER_127_349 VDD VDD VSS VSS gf180mcu_fd_sc_mcu7t5v0__fill_1
XTAP_TAPCELL_ROW_71_1208 VDD VSS gf180mcu_fd_sc_mcu7t5v0__filltie
XTAP_TAPCELL_ROW_131_1983 VDD VSS gf180mcu_fd_sc_mcu7t5v0__filltie
XFILLER_78_52 VDD VDD VSS VSS gf180mcu_fd_sc_mcu7t5v0__fillcap_4
XTAP_TAPCELL_ROW_131_1994 VDD VSS gf180mcu_fd_sc_mcu7t5v0__filltie
XFILLER_91_100 VDD VDD VSS VSS gf180mcu_fd_sc_mcu7t5v0__fill_1
XFILLER_64_325 VDD VDD VSS VSS gf180mcu_fd_sc_mcu7t5v0__fillcap_4
XFILLER_94_84 VDD VDD VSS VSS gf180mcu_fd_sc_mcu7t5v0__fillcap_16
XFILLER_92_667 VDD VDD VSS VSS gf180mcu_fd_sc_mcu7t5v0__fill_2
XFILLER_80_807 VDD VDD VSS VSS gf180mcu_fd_sc_mcu7t5v0__fillcap_16
XFILLER_64_369 VDD VDD VSS VSS gf180mcu_fd_sc_mcu7t5v0__fillcap_16
XTAP_TAPCELL_ROW_82_1348 VDD VSS gf180mcu_fd_sc_mcu7t5v0__filltie
X_3820_ _3820_/D _4109_/CLK _3820_/Q VDD VDD VSS VSS gf180mcu_fd_sc_mcu7t5v0__dffq_1
XTAP_TAPCELL_ROW_15_486 VDD VSS gf180mcu_fd_sc_mcu7t5v0__filltie
XTAP_TAPCELL_ROW_15_475 VDD VSS gf180mcu_fd_sc_mcu7t5v0__filltie
XFILLER_20_417 VDD VDD VSS VSS gf180mcu_fd_sc_mcu7t5v0__fillcap_8
XFILLER_60_597 VDD VDD VSS VSS gf180mcu_fd_sc_mcu7t5v0__fillcap_16
X_3751_ _3751_/D _3755_/CLK _3751_/Q VDD VDD VSS VSS gf180mcu_fd_sc_mcu7t5v0__dffq_1
XFILLER_118_305 VDD VDD VSS VSS gf180mcu_fd_sc_mcu7t5v0__fillcap_8
X_2702_ place87/Z _3808_/Q _2710_/S _3808_/D VDD VDD VSS VSS gf180mcu_fd_sc_mcu7t5v0__mux2_2
X_3682_ _3682_/D _4094_/CLK _3682_/Q VDD VDD VSS VSS gf180mcu_fd_sc_mcu7t5v0__dffq_1
X_2564_ _3751_/Q _4069_/Q _2574_/S _3751_/D VDD VDD VSS VSS gf180mcu_fd_sc_mcu7t5v0__mux2_2
XTAP_TAPCELL_ROW_93_1499 VDD VSS gf180mcu_fd_sc_mcu7t5v0__filltie
XFILLER_87_417 VDD VDD VSS VSS gf180mcu_fd_sc_mcu7t5v0__fill_2
X_2495_ _3720_/Q place81/Z _2503_/S _3720_/D VDD VDD VSS VSS gf180mcu_fd_sc_mcu7t5v0__mux2_2
XFILLER_114_599 VDD VDD VSS VSS gf180mcu_fd_sc_mcu7t5v0__fill_1
XFILLER_95_450 VDD VDD VSS VSS gf180mcu_fd_sc_mcu7t5v0__fill_2
X_4165_ _4165_/D input92/Z _4167_/CLK _4165_/Q VDD VDD VSS VSS gf180mcu_fd_sc_mcu7t5v0__dffrnq_1
XFILLER_56_804 VDD VDD VSS VSS gf180mcu_fd_sc_mcu7t5v0__fill_1
XFILLER_68_675 VDD VDD VSS VSS gf180mcu_fd_sc_mcu7t5v0__fillcap_4
XFILLER_95_472 VDD VDD VSS VSS gf180mcu_fd_sc_mcu7t5v0__fillcap_16
XFILLER_82_100 VDD VDD VSS VSS gf180mcu_fd_sc_mcu7t5v0__fillcap_4
XFILLER_55_314 VDD VDD VSS VSS gf180mcu_fd_sc_mcu7t5v0__fillcap_4
X_4096_ _4096_/D _2279_/I _4098_/CLK _4096_/Q VDD VDD VSS VSS gf180mcu_fd_sc_mcu7t5v0__dffrnq_1
XFILLER_82_177 VDD VDD VSS VSS gf180mcu_fd_sc_mcu7t5v0__fillcap_32
XFILLER_36_550 VDD VDD VSS VSS gf180mcu_fd_sc_mcu7t5v0__fillcap_32
XFILLER_70_317 VDD VDD VSS VSS gf180mcu_fd_sc_mcu7t5v0__fillcap_8
XFILLER_36_594 VDD VDD VSS VSS gf180mcu_fd_sc_mcu7t5v0__fill_1
X_3949_ _3949_/D _4157_/RN _3975_/CLK _3949_/Q VDD VDD VSS VSS gf180mcu_fd_sc_mcu7t5v0__dffrnq_1
XFILLER_99_18 VDD VDD VSS VSS gf180mcu_fd_sc_mcu7t5v0__fillcap_4
XFILLER_125_809 VDD VDD VSS VSS gf180mcu_fd_sc_mcu7t5v0__fillcap_16
XFILLER_109_349 VDD VDD VSS VSS gf180mcu_fd_sc_mcu7t5v0__fill_1
XTAP_TAPCELL_ROW_57_1030 VDD VSS gf180mcu_fd_sc_mcu7t5v0__filltie
XTAP_TAPCELL_ROW_109_1705 VDD VSS gf180mcu_fd_sc_mcu7t5v0__filltie
XFILLER_101_772 VDD VDD VSS VSS gf180mcu_fd_sc_mcu7t5v0__fillcap_16
XFILLER_74_623 VDD VDD VSS VSS gf180mcu_fd_sc_mcu7t5v0__fill_1
XFILLER_46_314 VDD VDD VSS VSS gf180mcu_fd_sc_mcu7t5v0__fill_1
XFILLER_46_325 VDD VDD VSS VSS gf180mcu_fd_sc_mcu7t5v0__fill_2
XFILLER_74_667 VDD VDD VSS VSS gf180mcu_fd_sc_mcu7t5v0__fillcap_8
XFILLER_73_133 VDD VDD VSS VSS gf180mcu_fd_sc_mcu7t5v0__fillcap_4
XFILLER_62_807 VDD VDD VSS VSS gf180mcu_fd_sc_mcu7t5v0__fillcap_8
XFILLER_61_306 VDD VDD VSS VSS gf180mcu_fd_sc_mcu7t5v0__fillcap_8
XTAP_TAPCELL_ROW_68_1170 VDD VSS gf180mcu_fd_sc_mcu7t5v0__filltie
XFILLER_14_244 VDD VDD VSS VSS gf180mcu_fd_sc_mcu7t5v0__fill_1
XFILLER_42_553 VDD VDD VSS VSS gf180mcu_fd_sc_mcu7t5v0__fill_2
XFILLER_42_564 VDD VDD VSS VSS gf180mcu_fd_sc_mcu7t5v0__fillcap_4
XFILLER_30_737 VDD VDD VSS VSS gf180mcu_fd_sc_mcu7t5v0__fillcap_4
XFILLER_42_597 VDD VDD VSS VSS gf180mcu_fd_sc_mcu7t5v0__fillcap_8
XTAP_TAPCELL_ROW_12_445 VDD VSS gf180mcu_fd_sc_mcu7t5v0__filltie
XFILLER_128_647 VDD VDD VSS VSS gf180mcu_fd_sc_mcu7t5v0__fill_2
XFILLER_10_450 VDD VDD VSS VSS gf180mcu_fd_sc_mcu7t5v0__fillcap_4
XFILLER_109_883 VDD VDD VSS VSS gf180mcu_fd_sc_mcu7t5v0__fill_1
XPHY_EDGE_ROW_108_Right_108 VDD VSS gf180mcu_fd_sc_mcu7t5v0__endcap
XFILLER_108_382 VDD VDD VSS VSS gf180mcu_fd_sc_mcu7t5v0__fill_2
XFILLER_69_417 VDD VDD VSS VSS gf180mcu_fd_sc_mcu7t5v0__fill_2
XFILLER_123_374 VDD VDD VSS VSS gf180mcu_fd_sc_mcu7t5v0__fill_1
XFILLER_97_759 VDD VDD VSS VSS gf180mcu_fd_sc_mcu7t5v0__fillcap_4
X_2280_ _4095_/Q _2360_/A2 _2300_/A3 VDD VDD VSS VSS gf180mcu_fd_sc_mcu7t5v0__nor2_1
XFILLER_111_558 VDD VDD VSS VSS gf180mcu_fd_sc_mcu7t5v0__fill_2
XFILLER_96_247 VDD VDD VSS VSS gf180mcu_fd_sc_mcu7t5v0__fillcap_16
XFILLER_38_804 VDD VDD VSS VSS gf180mcu_fd_sc_mcu7t5v0__fill_1
XFILLER_64_122 VDD VDD VSS VSS gf180mcu_fd_sc_mcu7t5v0__fillcap_32
XFILLER_52_317 VDD VDD VSS VSS gf180mcu_fd_sc_mcu7t5v0__fillcap_32
XFILLER_64_177 VDD VDD VSS VSS gf180mcu_fd_sc_mcu7t5v0__fill_2
XFILLER_18_594 VDD VDD VSS VSS gf180mcu_fd_sc_mcu7t5v0__fill_1
XFILLER_61_862 VDD VDD VSS VSS gf180mcu_fd_sc_mcu7t5v0__fill_2
X_3803_ _3803_/D clkload7/I _3803_/Q VDD VDD VSS VSS gf180mcu_fd_sc_mcu7t5v0__dffq_1
X_1995_ _1995_/A1 _1995_/A2 _1995_/B _4125_/D VDD VDD VSS VSS gf180mcu_fd_sc_mcu7t5v0__aoi21_1
XFILLER_20_247 VDD VDD VSS VSS gf180mcu_fd_sc_mcu7t5v0__fillcap_4
XFILLER_21_759 VDD VDD VSS VSS gf180mcu_fd_sc_mcu7t5v0__fillcap_8
XFILLER_20_269 VDD VDD VSS VSS gf180mcu_fd_sc_mcu7t5v0__fillcap_4
X_3734_ _3734_/D _3750_/CLK _3734_/Q VDD VDD VSS VSS gf180mcu_fd_sc_mcu7t5v0__dffq_1
XTAP_TAPCELL_ROW_95_1517 VDD VSS gf180mcu_fd_sc_mcu7t5v0__filltie
X_3665_ _3665_/D _3750_/CLK _3665_/Q VDD VDD VSS VSS gf180mcu_fd_sc_mcu7t5v0__dffq_1
Xclkload51 _3968_/CLK clkload51/Z VDD VDD VSS VSS gf180mcu_fd_sc_mcu7t5v0__clkbuf_2
Xclkload40 _3740_/CLK clkload40/Z VDD VDD VSS VSS gf180mcu_fd_sc_mcu7t5v0__clkbuf_2
XFILLER_115_842 VDD VDD VSS VSS gf180mcu_fd_sc_mcu7t5v0__fillcap_4
X_3596_ _3844_/Q _3852_/Q _3860_/Q _3868_/Q place76/Z place75/Z _3596_/Z VDD VDD VSS
+ VSS gf180mcu_fd_sc_mcu7t5v0__mux4_1
XFILLER_88_737 VDD VDD VSS VSS gf180mcu_fd_sc_mcu7t5v0__fillcap_32
XFILLER_102_547 VDD VDD VSS VSS gf180mcu_fd_sc_mcu7t5v0__fill_2
XFILLER_84_932 VDD VDD VSS VSS gf180mcu_fd_sc_mcu7t5v0__fill_2
XFILLER_28_314 VDD VDD VSS VSS gf180mcu_fd_sc_mcu7t5v0__fill_1
XFILLER_110_591 VDD VDD VSS VSS gf180mcu_fd_sc_mcu7t5v0__fillcap_4
XFILLER_44_807 VDD VDD VSS VSS gf180mcu_fd_sc_mcu7t5v0__fillcap_8
X_4148_ _4148_/D _4148_/RN _4148_/CLK _4148_/Q VDD VDD VSS VSS gf180mcu_fd_sc_mcu7t5v0__dffrnq_1
X_4079_ _4079_/D _4157_/RN _4109_/CLK _4079_/Q VDD VDD VSS VSS gf180mcu_fd_sc_mcu7t5v0__dffrnq_1
XFILLER_56_667 VDD VDD VSS VSS gf180mcu_fd_sc_mcu7t5v0__fillcap_64
XTAP_TAPCELL_ROW_104_1635 VDD VSS gf180mcu_fd_sc_mcu7t5v0__filltie
XFILLER_52_873 VDD VDD VSS VSS gf180mcu_fd_sc_mcu7t5v0__fill_2
XFILLER_12_737 VDD VDD VSS VSS gf180mcu_fd_sc_mcu7t5v0__fillcap_64
XFILLER_11_236 VDD VDD VSS VSS gf180mcu_fd_sc_mcu7t5v0__fillcap_32
Xclkload1 clkload1/I clkload1/Z VDD VDD VSS VSS gf180mcu_fd_sc_mcu7t5v0__clkbuf_8
XFILLER_109_146 VDD VDD VSS VSS gf180mcu_fd_sc_mcu7t5v0__fill_2
XFILLER_50_34 VDD VDD VSS VSS gf180mcu_fd_sc_mcu7t5v0__fill_1
XFILLER_50_67 VDD VDD VSS VSS gf180mcu_fd_sc_mcu7t5v0__fillcap_32
XFILLER_4_925 VDD VDD VSS VSS gf180mcu_fd_sc_mcu7t5v0__fillcap_8
XTAP_TAPCELL_ROW_115_1786 VDD VSS gf180mcu_fd_sc_mcu7t5v0__filltie
XTAP_TAPCELL_ROW_115_1775 VDD VSS gf180mcu_fd_sc_mcu7t5v0__filltie
XFILLER_105_352 VDD VDD VSS VSS gf180mcu_fd_sc_mcu7t5v0__fillcap_32
XFILLER_3_446 VDD VDD VSS VSS gf180mcu_fd_sc_mcu7t5v0__fill_2
XFILLER_3_479 VDD VDD VSS VSS gf180mcu_fd_sc_mcu7t5v0__fillcap_8
XFILLER_120_333 VDD VDD VSS VSS gf180mcu_fd_sc_mcu7t5v0__fillcap_4
XFILLER_78_247 VDD VDD VSS VSS gf180mcu_fd_sc_mcu7t5v0__fill_1
XFILLER_75_932 VDD VDD VSS VSS gf180mcu_fd_sc_mcu7t5v0__fill_2
XFILLER_59_483 VDD VDD VSS VSS gf180mcu_fd_sc_mcu7t5v0__fill_1
XFILLER_46_133 VDD VDD VSS VSS gf180mcu_fd_sc_mcu7t5v0__fillcap_8
XFILLER_59_494 VDD VDD VSS VSS gf180mcu_fd_sc_mcu7t5v0__fill_1
XTAP_TAPCELL_ROW_17_504 VDD VSS gf180mcu_fd_sc_mcu7t5v0__filltie
XFILLER_131_92 VDD VDD VSS VSS gf180mcu_fd_sc_mcu7t5v0__fill_2
XTAP_TAPCELL_ROW_45_868 VDD VSS gf180mcu_fd_sc_mcu7t5v0__filltie
XFILLER_61_158 VDD VDD VSS VSS gf180mcu_fd_sc_mcu7t5v0__fill_2
XFILLER_129_912 VDD VDD VSS VSS gf180mcu_fd_sc_mcu7t5v0__fillcap_16
XFILLER_91_96 VDD VDD VSS VSS gf180mcu_fd_sc_mcu7t5v0__fillcap_4
XFILLER_30_556 VDD VDD VSS VSS gf180mcu_fd_sc_mcu7t5v0__fill_1
XFILLER_42_383 VDD VDD VSS VSS gf180mcu_fd_sc_mcu7t5v0__fill_2
XFILLER_128_411 VDD VDD VSS VSS gf180mcu_fd_sc_mcu7t5v0__fillcap_4
XFILLER_30_567 VDD VDD VSS VSS gf180mcu_fd_sc_mcu7t5v0__fillcap_8
X_3450_ _3485_/A1 _3901_/Q _3453_/I0 _3450_/A4 _4102_/D VDD VDD VSS VSS gf180mcu_fd_sc_mcu7t5v0__and4_1
XFILLER_124_661 VDD VDD VSS VSS gf180mcu_fd_sc_mcu7t5v0__fillcap_4
X_3381_ _4085_/Q _4086_/Q _4157_/Q _3394_/A4 _3382_/B VDD VDD VSS VSS gf180mcu_fd_sc_mcu7t5v0__nand4_1
XTAP_TAPCELL_ROW_90_1458 VDD VSS gf180mcu_fd_sc_mcu7t5v0__filltie
X_2332_ _4071_/Q _3649_/Q _2338_/S _3649_/D VDD VDD VSS VSS gf180mcu_fd_sc_mcu7t5v0__mux2_2
XFILLER_27_2 VDD VDD VSS VSS gf180mcu_fd_sc_mcu7t5v0__fillcap_16
XFILLER_57_409 VDD VDD VSS VSS gf180mcu_fd_sc_mcu7t5v0__fillcap_8
X_2263_ _2263_/I _2263_/ZN VDD VDD VSS VSS gf180mcu_fd_sc_mcu7t5v0__inv_1
X_4002_ _4002_/D _4148_/RN _4036_/CLK _4002_/Q VDD VDD VSS VSS gf180mcu_fd_sc_mcu7t5v0__dffrnq_1
XFILLER_1_72 VDD VDD VSS VSS gf180mcu_fd_sc_mcu7t5v0__fillcap_64
XFILLER_25_306 VDD VDD VSS VSS gf180mcu_fd_sc_mcu7t5v0__fill_1
XFILLER_26_807 VDD VDD VSS VSS gf180mcu_fd_sc_mcu7t5v0__fillcap_32
XFILLER_38_667 VDD VDD VSS VSS gf180mcu_fd_sc_mcu7t5v0__fillcap_8
XFILLER_18_391 VDD VDD VSS VSS gf180mcu_fd_sc_mcu7t5v0__fill_1
XFILLER_40_309 VDD VDD VSS VSS gf180mcu_fd_sc_mcu7t5v0__fillcap_4
XFILLER_119_422 VDD VDD VSS VSS gf180mcu_fd_sc_mcu7t5v0__fillcap_64
X_1978_ _3969_/Q _1993_/C VDD VDD VSS VSS gf180mcu_fd_sc_mcu7t5v0__clkinv_1
X_3717_ _3717_/D _3733_/CLK _3717_/Q VDD VDD VSS VSS gf180mcu_fd_sc_mcu7t5v0__dffq_1
XTAP_TAPCELL_ROW_132_2020 VDD VSS gf180mcu_fd_sc_mcu7t5v0__filltie
XFILLER_20_37 VDD VDD VSS VSS gf180mcu_fd_sc_mcu7t5v0__fillcap_4
X_3648_ _3648_/D _4114_/CLK _3648_/Q VDD VDD VSS VSS gf180mcu_fd_sc_mcu7t5v0__dffq_1
XFILLER_1_906 VDD VDD VSS VSS gf180mcu_fd_sc_mcu7t5v0__fillcap_4
X_3579_ _3578_/Z _4153_/Q _3600_/S _4153_/D VDD VDD VSS VSS gf180mcu_fd_sc_mcu7t5v0__mux2_2
XFILLER_114_171 VDD VDD VSS VSS gf180mcu_fd_sc_mcu7t5v0__fillcap_4
XFILLER_102_311 VDD VDD VSS VSS gf180mcu_fd_sc_mcu7t5v0__fillcap_4
XFILLER_1_928 VDD VDD VSS VSS gf180mcu_fd_sc_mcu7t5v0__fillcap_4
XFILLER_130_664 VDD VDD VSS VSS gf180mcu_fd_sc_mcu7t5v0__fill_1
XFILLER_75_206 VDD VDD VSS VSS gf180mcu_fd_sc_mcu7t5v0__fillcap_4
XFILLER_57_932 VDD VDD VSS VSS gf180mcu_fd_sc_mcu7t5v0__fill_2
XFILLER_17_829 VDD VDD VSS VSS gf180mcu_fd_sc_mcu7t5v0__fillcap_8
XFILLER_29_678 VDD VDD VSS VSS gf180mcu_fd_sc_mcu7t5v0__fillcap_16
XFILLER_16_317 VDD VDD VSS VSS gf180mcu_fd_sc_mcu7t5v0__fillcap_64
XFILLER_28_177 VDD VDD VSS VSS gf180mcu_fd_sc_mcu7t5v0__fillcap_8
XFILLER_43_136 VDD VDD VSS VSS gf180mcu_fd_sc_mcu7t5v0__fillcap_4
XFILLER_45_67 VDD VDD VSS VSS gf180mcu_fd_sc_mcu7t5v0__fill_2
XTAP_TAPCELL_ROW_42_827 VDD VSS gf180mcu_fd_sc_mcu7t5v0__filltie
XTAP_TAPCELL_ROW_42_838 VDD VSS gf180mcu_fd_sc_mcu7t5v0__filltie
XFILLER_101_62 VDD VDD VSS VSS gf180mcu_fd_sc_mcu7t5v0__fillcap_8
XFILLER_12_523 VDD VDD VSS VSS gf180mcu_fd_sc_mcu7t5v0__fill_2
XFILLER_8_527 VDD VDD VSS VSS gf180mcu_fd_sc_mcu7t5v0__fillcap_8
XTAP_TAPCELL_ROW_117_1804 VDD VSS gf180mcu_fd_sc_mcu7t5v0__filltie
XTAP_TAPCELL_ROW_22_573 VDD VSS gf180mcu_fd_sc_mcu7t5v0__filltie
XFILLER_61_99 VDD VDD VSS VSS gf180mcu_fd_sc_mcu7t5v0__fillcap_32
XFILLER_3_243 VDD VDD VSS VSS gf180mcu_fd_sc_mcu7t5v0__fillcap_8
XFILLER_106_672 VDD VDD VSS VSS gf180mcu_fd_sc_mcu7t5v0__fill_2
XTAP_TAPCELL_ROW_76_1280 VDD VSS gf180mcu_fd_sc_mcu7t5v0__filltie
XFILLER_79_556 VDD VDD VSS VSS gf180mcu_fd_sc_mcu7t5v0__fillcap_4
XFILLER_120_152 VDD VDD VSS VSS gf180mcu_fd_sc_mcu7t5v0__fillcap_16
XFILLER_120_174 VDD VDD VSS VSS gf180mcu_fd_sc_mcu7t5v0__fill_1
XFILLER_86_85 VDD VDD VSS VSS gf180mcu_fd_sc_mcu7t5v0__fillcap_16
XTAP_TAPCELL_ROW_128_1955 VDD VSS gf180mcu_fd_sc_mcu7t5v0__filltie
XTAP_TAPCELL_ROW_128_1944 VDD VSS gf180mcu_fd_sc_mcu7t5v0__filltie
XFILLER_47_453 VDD VDD VSS VSS gf180mcu_fd_sc_mcu7t5v0__fillcap_8
XFILLER_35_648 VDD VDD VSS VSS gf180mcu_fd_sc_mcu7t5v0__fillcap_8
XFILLER_62_434 VDD VDD VSS VSS gf180mcu_fd_sc_mcu7t5v0__fillcap_16
X_2950_ _4041_/Q _3921_/Q _2972_/S _3921_/D VDD VDD VSS VSS gf180mcu_fd_sc_mcu7t5v0__mux2_2
XFILLER_34_169 VDD VDD VSS VSS gf180mcu_fd_sc_mcu7t5v0__fillcap_4
XFILLER_62_489 VDD VDD VSS VSS gf180mcu_fd_sc_mcu7t5v0__fillcap_16
X_1901_ _3893_/Q _2058_/A1 _1901_/B _1901_/C _1908_/A1 VDD VDD VSS VSS gf180mcu_fd_sc_mcu7t5v0__aoi211_1
X_2881_ _2881_/A1 _2900_/S _2881_/B _3888_/D VDD VDD VSS VSS gf180mcu_fd_sc_mcu7t5v0__oai21_1
XFILLER_31_832 VDD VDD VSS VSS gf180mcu_fd_sc_mcu7t5v0__fillcap_8
X_1832_ _1837_/A2 _1837_/A3 _1832_/Z VDD VDD VSS VSS gf180mcu_fd_sc_mcu7t5v0__and2_1
XTAP_TAPCELL_ROW_79_1309 VDD VSS gf180mcu_fd_sc_mcu7t5v0__filltie
XFILLER_129_764 VDD VDD VSS VSS gf180mcu_fd_sc_mcu7t5v0__fillcap_4
X_3502_ _4110_/Q _2578_/Z _3508_/A2 _3503_/B VDD VDD VSS VSS gf180mcu_fd_sc_mcu7t5v0__nand3_1
X_3433_ _4103_/Q _3485_/B VDD VDD VSS VSS gf180mcu_fd_sc_mcu7t5v0__clkinv_1
X_3364_ _4083_/Q _3365_/A2 _3366_/A2 VDD VDD VSS VSS gf180mcu_fd_sc_mcu7t5v0__nor2_1
XFILLER_112_664 VDD VDD VSS VSS gf180mcu_fd_sc_mcu7t5v0__fill_1
XFILLER_100_804 VDD VDD VSS VSS gf180mcu_fd_sc_mcu7t5v0__fill_1
XFILLER_97_375 VDD VDD VSS VSS gf180mcu_fd_sc_mcu7t5v0__fillcap_16
X_2315_ _3642_/Q place80/Z _2319_/S _3642_/D VDD VDD VSS VSS gf180mcu_fd_sc_mcu7t5v0__mux2_2
XPHY_EDGE_ROW_29_Left_162 VDD VSS gf180mcu_fd_sc_mcu7t5v0__endcap
X_3295_ _4066_/Q _3285_/Z _3902_/Q _3296_/B VDD VDD VSS VSS gf180mcu_fd_sc_mcu7t5v0__oai21_1
XFILLER_57_206 VDD VDD VSS VSS gf180mcu_fd_sc_mcu7t5v0__fillcap_4
X_2246_ _3950_/Q place63/Z place67/Z _3975_/Q _3918_/Q place72/Z _2247_/I VDD VDD
+ VSS VSS gf180mcu_fd_sc_mcu7t5v0__aoi222_1
XFILLER_85_559 VDD VDD VSS VSS gf180mcu_fd_sc_mcu7t5v0__fill_1
XFILLER_39_932 VDD VDD VSS VSS gf180mcu_fd_sc_mcu7t5v0__fill_2
X_2177_ _2152_/S _2177_/A2 _2177_/Z VDD VDD VSS VSS gf180mcu_fd_sc_mcu7t5v0__and2_1
XFILLER_81_710 VDD VDD VSS VSS gf180mcu_fd_sc_mcu7t5v0__fill_2
XFILLER_25_114 VDD VDD VSS VSS gf180mcu_fd_sc_mcu7t5v0__fillcap_16
XFILLER_38_497 VDD VDD VSS VSS gf180mcu_fd_sc_mcu7t5v0__fillcap_16
XFILLER_53_412 VDD VDD VSS VSS gf180mcu_fd_sc_mcu7t5v0__fillcap_8
XTAP_TAPCELL_ROW_0_279 VDD VSS gf180mcu_fd_sc_mcu7t5v0__filltie
XTAP_TAPCELL_ROW_0_268 VDD VSS gf180mcu_fd_sc_mcu7t5v0__filltie
XTAP_TAPCELL_ROW_101_1605 VDD VSS gf180mcu_fd_sc_mcu7t5v0__filltie
XFILLER_53_489 VDD VDD VSS VSS gf180mcu_fd_sc_mcu7t5v0__fill_1
XPHY_EDGE_ROW_38_Left_171 VDD VSS gf180mcu_fd_sc_mcu7t5v0__endcap
XTAP_TAPCELL_ROW_60_1070 VDD VSS gf180mcu_fd_sc_mcu7t5v0__filltie
XFILLER_31_58 VDD VDD VSS VSS gf180mcu_fd_sc_mcu7t5v0__fillcap_8
XTAP_TAPCELL_ROW_112_1745 VDD VSS gf180mcu_fd_sc_mcu7t5v0__filltie
XPHY_EDGE_ROW_47_Left_180 VDD VSS gf180mcu_fd_sc_mcu7t5v0__endcap
Xinput125 hold204/Z _3146_/I1 VDD VDD VSS VSS gf180mcu_fd_sc_mcu7t5v0__dlyb_1
Xinput114 hold213/Z _3125_/I1 VDD VDD VSS VSS gf180mcu_fd_sc_mcu7t5v0__dlyb_1
Xinput103 hold231/Z _3090_/I1 VDD VDD VSS VSS gf180mcu_fd_sc_mcu7t5v0__dlyb_1
Xinput136 hold192/Z _3106_/I1 VDD VDD VSS VSS gf180mcu_fd_sc_mcu7t5v0__dlyb_1
XFILLER_63_209 VDD VDD VSS VSS gf180mcu_fd_sc_mcu7t5v0__fill_1
XFILLER_17_626 VDD VDD VSS VSS gf180mcu_fd_sc_mcu7t5v0__fillcap_4
XFILLER_29_486 VDD VDD VSS VSS gf180mcu_fd_sc_mcu7t5v0__fillcap_4
XTAP_TAPCELL_ROW_27_632 VDD VSS gf180mcu_fd_sc_mcu7t5v0__filltie
XTAP_TAPCELL_ROW_27_643 VDD VSS gf180mcu_fd_sc_mcu7t5v0__filltie
XTAP_TAPCELL_ROW_55_996 VDD VSS gf180mcu_fd_sc_mcu7t5v0__filltie
XTAP_TAPCELL_ROW_123_1885 VDD VSS gf180mcu_fd_sc_mcu7t5v0__filltie
XFILLER_125_222 VDD VDD VSS VSS gf180mcu_fd_sc_mcu7t5v0__fillcap_16
XFILLER_113_428 VDD VDD VSS VSS gf180mcu_fd_sc_mcu7t5v0__fill_1
XFILLER_99_629 VDD VDD VSS VSS gf180mcu_fd_sc_mcu7t5v0__fill_1
XFILLER_39_206 VDD VDD VSS VSS gf180mcu_fd_sc_mcu7t5v0__fillcap_4
X_2100_ input94/Z input93/Z input98/Z _2109_/I VDD VDD VSS VSS gf180mcu_fd_sc_mcu7t5v0__or3_2
X_2031_ _2013_/Z _2030_/Z _2033_/A2 VDD VDD VSS VSS gf180mcu_fd_sc_mcu7t5v0__nor2_1
XFILLER_23_629 VDD VDD VSS VSS gf180mcu_fd_sc_mcu7t5v0__fill_1
X_3982_ _3982_/D input92/Z clkload9/I _3982_/Q VDD VDD VSS VSS gf180mcu_fd_sc_mcu7t5v0__dffrnq_1
X_2933_ _4033_/Q _3913_/Q _2972_/S _3913_/D VDD VDD VSS VSS gf180mcu_fd_sc_mcu7t5v0__mux2_2
XFILLER_22_139 VDD VDD VSS VSS gf180mcu_fd_sc_mcu7t5v0__fillcap_4
XFILLER_30_172 VDD VDD VSS VSS gf180mcu_fd_sc_mcu7t5v0__fill_2
X_1815_ _4144_/Q _1835_/B VDD VDD VSS VSS gf180mcu_fd_sc_mcu7t5v0__clkinv_1
X_2795_ place85/Z _3850_/Q _2799_/S _3850_/D VDD VDD VSS VSS gf180mcu_fd_sc_mcu7t5v0__mux2_2
XFILLER_117_734 VDD VDD VSS VSS gf180mcu_fd_sc_mcu7t5v0__fillcap_8
XFILLER_89_139 VDD VDD VSS VSS gf180mcu_fd_sc_mcu7t5v0__fill_1
X_3416_ _4099_/Q _3438_/A1 VDD VDD VSS VSS gf180mcu_fd_sc_mcu7t5v0__clkinv_1
XFILLER_100_601 VDD VDD VSS VSS gf180mcu_fd_sc_mcu7t5v0__fill_2
X_3347_ _3906_/Q _3342_/B _3347_/B _3349_/A2 VDD VDD VSS VSS gf180mcu_fd_sc_mcu7t5v0__aoi21_1
XFILLER_58_504 VDD VDD VSS VSS gf180mcu_fd_sc_mcu7t5v0__fillcap_8
XFILLER_100_612 VDD VDD VSS VSS gf180mcu_fd_sc_mcu7t5v0__fillcap_8
XTAP_TAPCELL_ROW_5_349 VDD VSS gf180mcu_fd_sc_mcu7t5v0__filltie
XFILLER_100_667 VDD VDD VSS VSS gf180mcu_fd_sc_mcu7t5v0__fillcap_64
XFILLER_86_879 VDD VDD VSS VSS gf180mcu_fd_sc_mcu7t5v0__fill_1
XFILLER_85_345 VDD VDD VSS VSS gf180mcu_fd_sc_mcu7t5v0__fillcap_4
X_3278_ _3278_/A1 _3278_/A2 _3627_/I1 VDD VDD VSS VSS gf180mcu_fd_sc_mcu7t5v0__nand2_1
X_2229_ _3895_/Q place68/Z place63/Z _3943_/Q place67/Z _4087_/Q _2230_/A2 VDD VDD
+ VSS VSS gf180mcu_fd_sc_mcu7t5v0__aoi222_1
XFILLER_53_231 VDD VDD VSS VSS gf180mcu_fd_sc_mcu7t5v0__fill_1
XFILLER_81_562 VDD VDD VSS VSS gf180mcu_fd_sc_mcu7t5v0__fillcap_64
XTAP_TAPCELL_ROW_24_602 VDD VSS gf180mcu_fd_sc_mcu7t5v0__filltie
XFILLER_53_264 VDD VDD VSS VSS gf180mcu_fd_sc_mcu7t5v0__fillcap_16
XFILLER_13_139 VDD VDD VSS VSS gf180mcu_fd_sc_mcu7t5v0__fill_1
XFILLER_10_802 VDD VDD VSS VSS gf180mcu_fd_sc_mcu7t5v0__fill_2
XTAP_TAPCELL_ROW_52_966 VDD VSS gf180mcu_fd_sc_mcu7t5v0__filltie
XFILLER_108_734 VDD VDD VSS VSS gf180mcu_fd_sc_mcu7t5v0__fill_1
XFILLER_107_244 VDD VDD VSS VSS gf180mcu_fd_sc_mcu7t5v0__fillcap_4
XFILLER_123_726 VDD VDD VSS VSS gf180mcu_fd_sc_mcu7t5v0__fillcap_4
XFILLER_122_247 VDD VDD VSS VSS gf180mcu_fd_sc_mcu7t5v0__fillcap_16
XFILLER_107_72 VDD VDD VSS VSS gf180mcu_fd_sc_mcu7t5v0__fillcap_8
XFILLER_77_835 VDD VDD VSS VSS gf180mcu_fd_sc_mcu7t5v0__fillcap_4
XFILLER_76_367 VDD VDD VSS VSS gf180mcu_fd_sc_mcu7t5v0__fillcap_16
XTAP_TAPCELL_ROW_125_1914 VDD VSS gf180mcu_fd_sc_mcu7t5v0__filltie
XFILLER_44_231 VDD VDD VSS VSS gf180mcu_fd_sc_mcu7t5v0__fillcap_8
XFILLER_45_754 VDD VDD VSS VSS gf180mcu_fd_sc_mcu7t5v0__fill_1
XFILLER_9_699 VDD VDD VSS VSS gf180mcu_fd_sc_mcu7t5v0__fill_1
X_2580_ _4157_/RN _2578_/Z _2766_/A3 VDD VDD VSS VSS gf180mcu_fd_sc_mcu7t5v0__nand2_2
XFILLER_126_597 VDD VDD VSS VSS gf180mcu_fd_sc_mcu7t5v0__fill_2
XFILLER_114_737 VDD VDD VSS VSS gf180mcu_fd_sc_mcu7t5v0__fillcap_64
XFILLER_4_382 VDD VDD VSS VSS gf180mcu_fd_sc_mcu7t5v0__fill_2
XFILLER_86_109 VDD VDD VSS VSS gf180mcu_fd_sc_mcu7t5v0__fill_1
XFILLER_79_150 VDD VDD VSS VSS gf180mcu_fd_sc_mcu7t5v0__fillcap_4
XFILLER_110_932 VDD VDD VSS VSS gf180mcu_fd_sc_mcu7t5v0__fill_2
XFILLER_95_632 VDD VDD VSS VSS gf180mcu_fd_sc_mcu7t5v0__fillcap_64
XFILLER_67_312 VDD VDD VSS VSS gf180mcu_fd_sc_mcu7t5v0__fillcap_32
XFILLER_83_805 VDD VDD VSS VSS gf180mcu_fd_sc_mcu7t5v0__fill_2
XTAP_TAPCELL_ROW_2_308 VDD VSS gf180mcu_fd_sc_mcu7t5v0__filltie
XTAP_TAPCELL_ROW_87_1419 VDD VSS gf180mcu_fd_sc_mcu7t5v0__filltie
XFILLER_27_209 VDD VDD VSS VSS gf180mcu_fd_sc_mcu7t5v0__fill_1
X_3063_ _3973_/Q _3459_/A1 VDD VDD VSS VSS gf180mcu_fd_sc_mcu7t5v0__clkinv_1
X_2014_ _4132_/Q _2013_/Z _2016_/A2 VDD VDD VSS VSS gf180mcu_fd_sc_mcu7t5v0__nor2_1
XFILLER_51_702 VDD VDD VSS VSS gf180mcu_fd_sc_mcu7t5v0__fillcap_16
XFILLER_63_562 VDD VDD VSS VSS gf180mcu_fd_sc_mcu7t5v0__fillcap_64
XFILLER_90_370 VDD VDD VSS VSS gf180mcu_fd_sc_mcu7t5v0__fillcap_8
XFILLER_35_275 VDD VDD VSS VSS gf180mcu_fd_sc_mcu7t5v0__fillcap_4
X_3965_ _3965_/D _2279_/I _3978_/CLK _3965_/Q VDD VDD VSS VSS gf180mcu_fd_sc_mcu7t5v0__dffsnq_1
XFILLER_51_768 VDD VDD VSS VSS gf180mcu_fd_sc_mcu7t5v0__fill_2
X_3896_ _3896_/D _4157_/RN _3946_/CLK _3896_/Q VDD VDD VSS VSS gf180mcu_fd_sc_mcu7t5v0__dffrnq_1
X_2916_ _4025_/Q place91/Z _2972_/S _3905_/D VDD VDD VSS VSS gf180mcu_fd_sc_mcu7t5v0__mux2_2
XFILLER_31_492 VDD VDD VSS VSS gf180mcu_fd_sc_mcu7t5v0__fillcap_32
XFILLER_128_27 VDD VDD VSS VSS gf180mcu_fd_sc_mcu7t5v0__fillcap_8
XFILLER_117_520 VDD VDD VSS VSS gf180mcu_fd_sc_mcu7t5v0__fill_2
XTAP_TAPCELL_ROW_98_1559 VDD VSS gf180mcu_fd_sc_mcu7t5v0__filltie
XFILLER_117_553 VDD VDD VSS VSS gf180mcu_fd_sc_mcu7t5v0__fillcap_4
X_2778_ place85/Z _3842_/Q _2782_/S _3842_/D VDD VDD VSS VSS gf180mcu_fd_sc_mcu7t5v0__mux2_2
XFILLER_104_247 VDD VDD VSS VSS gf180mcu_fd_sc_mcu7t5v0__fillcap_16
XFILLER_132_567 VDD VDD VSS VSS gf180mcu_fd_sc_mcu7t5v0__fillcap_8
Xhold198 s_axi_awaddr[1] hold198/Z VDD VDD VSS VSS gf180mcu_fd_sc_mcu7t5v0__dlyc_1
XFILLER_58_323 VDD VDD VSS VSS gf180mcu_fd_sc_mcu7t5v0__fill_1
XFILLER_86_643 VDD VDD VSS VSS gf180mcu_fd_sc_mcu7t5v0__fillcap_16
XFILLER_85_142 VDD VDD VSS VSS gf180mcu_fd_sc_mcu7t5v0__fillcap_64
XFILLER_100_497 VDD VDD VSS VSS gf180mcu_fd_sc_mcu7t5v0__fill_1
XFILLER_26_231 VDD VDD VSS VSS gf180mcu_fd_sc_mcu7t5v0__fillcap_8
XFILLER_27_754 VDD VDD VSS VSS gf180mcu_fd_sc_mcu7t5v0__fillcap_16
XTAP_TAPCELL_ROW_107_1677 VDD VSS gf180mcu_fd_sc_mcu7t5v0__filltie
XTAP_TAPCELL_ROW_37_771 VDD VSS gf180mcu_fd_sc_mcu7t5v0__filltie
XFILLER_41_212 VDD VDD VSS VSS gf180mcu_fd_sc_mcu7t5v0__fill_1
XTAP_TAPCELL_ROW_120_1844 VDD VSS gf180mcu_fd_sc_mcu7t5v0__filltie
XFILLER_128_807 VDD VDD VSS VSS gf180mcu_fd_sc_mcu7t5v0__fillcap_32
XFILLER_118_93 VDD VDD VSS VSS gf180mcu_fd_sc_mcu7t5v0__fillcap_8
XTAP_TAPCELL_ROW_71_1209 VDD VSS gf180mcu_fd_sc_mcu7t5v0__filltie
XTAP_TAPCELL_ROW_131_1984 VDD VSS gf180mcu_fd_sc_mcu7t5v0__filltie
XFILLER_123_556 VDD VDD VSS VSS gf180mcu_fd_sc_mcu7t5v0__fillcap_4
XFILLER_1_341 VDD VDD VSS VSS gf180mcu_fd_sc_mcu7t5v0__fillcap_8
XFILLER_1_352 VDD VDD VSS VSS gf180mcu_fd_sc_mcu7t5v0__fillcap_8
XTAP_TAPCELL_ROW_131_1995 VDD VSS gf180mcu_fd_sc_mcu7t5v0__filltie
XFILLER_89_492 VDD VDD VSS VSS gf180mcu_fd_sc_mcu7t5v0__fillcap_64
XFILLER_77_632 VDD VDD VSS VSS gf180mcu_fd_sc_mcu7t5v0__fillcap_4
XFILLER_94_52 VDD VDD VSS VSS gf180mcu_fd_sc_mcu7t5v0__fillcap_32
XFILLER_92_657 VDD VDD VSS VSS gf180mcu_fd_sc_mcu7t5v0__fill_1
XFILLER_64_337 VDD VDD VSS VSS gf180mcu_fd_sc_mcu7t5v0__fillcap_32
XFILLER_92_679 VDD VDD VSS VSS gf180mcu_fd_sc_mcu7t5v0__fillcap_16
XFILLER_33_702 VDD VDD VSS VSS gf180mcu_fd_sc_mcu7t5v0__fillcap_64
XFILLER_45_562 VDD VDD VSS VSS gf180mcu_fd_sc_mcu7t5v0__fillcap_4
XTAP_TAPCELL_ROW_82_1349 VDD VSS gf180mcu_fd_sc_mcu7t5v0__filltie
XTAP_TAPCELL_ROW_15_487 VDD VSS gf180mcu_fd_sc_mcu7t5v0__filltie
XTAP_TAPCELL_ROW_15_476 VDD VSS gf180mcu_fd_sc_mcu7t5v0__filltie
X_3750_ _3750_/D _3750_/CLK _3750_/Q VDD VDD VSS VSS gf180mcu_fd_sc_mcu7t5v0__dffq_1
XFILLER_13_492 VDD VDD VSS VSS gf180mcu_fd_sc_mcu7t5v0__fillcap_8
XFILLER_118_317 VDD VDD VSS VSS gf180mcu_fd_sc_mcu7t5v0__fillcap_64
X_3681_ _3681_/D _4157_/CLK _3681_/Q VDD VDD VSS VSS gf180mcu_fd_sc_mcu7t5v0__dffq_1
X_2632_ place86/Z _3777_/Q _2638_/S _3777_/D VDD VDD VSS VSS gf180mcu_fd_sc_mcu7t5v0__mux2_2
XFILLER_99_212 VDD VDD VSS VSS gf180mcu_fd_sc_mcu7t5v0__fillcap_64
XTAP_TAPCELL_ROW_93_1489 VDD VSS gf180mcu_fd_sc_mcu7t5v0__filltie
XFILLER_101_228 VDD VDD VSS VSS gf180mcu_fd_sc_mcu7t5v0__fillcap_4
XFILLER_101_206 VDD VDD VSS VSS gf180mcu_fd_sc_mcu7t5v0__fillcap_4
X_4164_ _4164_/D input92/Z _4166_/CLK _4164_/Q VDD VDD VSS VSS gf180mcu_fd_sc_mcu7t5v0__dffrnq_1
XFILLER_67_142 VDD VDD VSS VSS gf180mcu_fd_sc_mcu7t5v0__fillcap_64
X_4095_ _4095_/D _2279_/I _4098_/CLK _4095_/Q VDD VDD VSS VSS gf180mcu_fd_sc_mcu7t5v0__dffrnq_1
X_3115_ _3998_/Q _3115_/I1 _3160_/S _3998_/D VDD VDD VSS VSS gf180mcu_fd_sc_mcu7t5v0__mux2_2
X_3046_ _4045_/Q _3965_/Q _3081_/S _3965_/D VDD VDD VSS VSS gf180mcu_fd_sc_mcu7t5v0__mux2_2
XFILLER_55_348 VDD VDD VSS VSS gf180mcu_fd_sc_mcu7t5v0__fill_2
XFILLER_64_871 VDD VDD VSS VSS gf180mcu_fd_sc_mcu7t5v0__fillcap_4
XFILLER_130_28 VDD VDD VSS VSS gf180mcu_fd_sc_mcu7t5v0__fillcap_4
XFILLER_23_212 VDD VDD VSS VSS gf180mcu_fd_sc_mcu7t5v0__fillcap_64
XFILLER_64_893 VDD VDD VSS VSS gf180mcu_fd_sc_mcu7t5v0__fillcap_8
XTAP_TAPCELL_ROW_34_730 VDD VSS gf180mcu_fd_sc_mcu7t5v0__filltie
XFILLER_51_554 VDD VDD VSS VSS gf180mcu_fd_sc_mcu7t5v0__fillcap_4
X_3948_ _3948_/D _4157_/RN _3975_/CLK _3948_/Q VDD VDD VSS VSS gf180mcu_fd_sc_mcu7t5v0__dffrnq_1
X_3879_ _3879_/D _4148_/CLK _3879_/Q VDD VDD VSS VSS gf180mcu_fd_sc_mcu7t5v0__dffq_1
XTAP_TAPCELL_ROW_57_1031 VDD VSS gf180mcu_fd_sc_mcu7t5v0__filltie
XFILLER_132_342 VDD VDD VSS VSS gf180mcu_fd_sc_mcu7t5v0__fillcap_32
XFILLER_48_34 VDD VDD VSS VSS gf180mcu_fd_sc_mcu7t5v0__fill_1
XFILLER_59_632 VDD VDD VSS VSS gf180mcu_fd_sc_mcu7t5v0__fillcap_64
XTAP_TAPCELL_ROW_109_1706 VDD VSS gf180mcu_fd_sc_mcu7t5v0__filltie
XFILLER_86_462 VDD VDD VSS VSS gf180mcu_fd_sc_mcu7t5v0__fillcap_16
XFILLER_74_613 VDD VDD VSS VSS gf180mcu_fd_sc_mcu7t5v0__fillcap_8
XFILLER_15_702 VDD VDD VSS VSS gf180mcu_fd_sc_mcu7t5v0__fillcap_16
XFILLER_27_562 VDD VDD VSS VSS gf180mcu_fd_sc_mcu7t5v0__fillcap_16
XFILLER_42_521 VDD VDD VSS VSS gf180mcu_fd_sc_mcu7t5v0__fillcap_4
XTAP_TAPCELL_ROW_68_1171 VDD VSS gf180mcu_fd_sc_mcu7t5v0__filltie
XFILLER_120_94 VDD VDD VSS VSS gf180mcu_fd_sc_mcu7t5v0__fillcap_8
XTAP_TAPCELL_ROW_12_446 VDD VSS gf180mcu_fd_sc_mcu7t5v0__filltie
XFILLER_7_912 VDD VDD VSS VSS gf180mcu_fd_sc_mcu7t5v0__fillcap_16
XFILLER_127_136 VDD VDD VSS VSS gf180mcu_fd_sc_mcu7t5v0__fillcap_4
XFILLER_109_873 VDD VDD VSS VSS gf180mcu_fd_sc_mcu7t5v0__fillcap_8
XFILLER_111_526 VDD VDD VSS VSS gf180mcu_fd_sc_mcu7t5v0__fillcap_8
XFILLER_2_683 VDD VDD VSS VSS gf180mcu_fd_sc_mcu7t5v0__fillcap_4
XFILLER_29_6 VDD VDD VSS VSS gf180mcu_fd_sc_mcu7t5v0__fill_1
XFILLER_93_933 VDD VDD VSS VSS gf180mcu_fd_sc_mcu7t5v0__fill_1
XFILLER_77_484 VDD VDD VSS VSS gf180mcu_fd_sc_mcu7t5v0__fillcap_4
XFILLER_49_142 VDD VDD VSS VSS gf180mcu_fd_sc_mcu7t5v0__fillcap_64
XFILLER_64_101 VDD VDD VSS VSS gf180mcu_fd_sc_mcu7t5v0__fillcap_4
XFILLER_46_871 VDD VDD VSS VSS gf180mcu_fd_sc_mcu7t5v0__fillcap_4
XFILLER_46_893 VDD VDD VSS VSS gf180mcu_fd_sc_mcu7t5v0__fillcap_8
X_3802_ _3802_/D clkload8/I _3802_/Q VDD VDD VSS VSS gf180mcu_fd_sc_mcu7t5v0__dffq_1
X_1994_ _3972_/Q _3971_/Q _3970_/Q _1995_/B VDD VDD VSS VSS gf180mcu_fd_sc_mcu7t5v0__or3_1
X_3733_ _3733_/D _3733_/CLK _3733_/Q VDD VDD VSS VSS gf180mcu_fd_sc_mcu7t5v0__dffq_1
XTAP_TAPCELL_ROW_95_1518 VDD VSS gf180mcu_fd_sc_mcu7t5v0__filltie
XFILLER_9_282 VDD VDD VSS VSS gf180mcu_fd_sc_mcu7t5v0__fillcap_8
X_3664_ _3664_/D _4108_/CLK _3664_/Q VDD VDD VSS VSS gf180mcu_fd_sc_mcu7t5v0__dffq_1
Xclkload30 _3946_/CLK clkload30/Z VDD VDD VSS VSS gf180mcu_fd_sc_mcu7t5v0__clkbuf_2
Xclkload52 _4098_/CLK clkload52/Z VDD VDD VSS VSS gf180mcu_fd_sc_mcu7t5v0__clkbuf_2
Xclkload41 _3750_/CLK clkload41/ZN VDD VDD VSS VSS gf180mcu_fd_sc_mcu7t5v0__clkinv_1
X_2615_ place85/Z _3770_/Q _2619_/S _3770_/D VDD VDD VSS VSS gf180mcu_fd_sc_mcu7t5v0__mux2_2
X_3595_ _3764_/Q _3820_/Q _3828_/Q _3836_/Q _4116_/Q place75/Z _3595_/Z VDD VDD VSS
+ VSS gf180mcu_fd_sc_mcu7t5v0__mux4_1
XFILLER_130_802 VDD VDD VSS VSS gf180mcu_fd_sc_mcu7t5v0__fill_2
X_2546_ _3743_/Q _4069_/Q _2556_/S _3743_/D VDD VDD VSS VSS gf180mcu_fd_sc_mcu7t5v0__mux2_2
XPHY_EDGE_ROW_10_Left_143 VDD VSS gf180mcu_fd_sc_mcu7t5v0__endcap
X_2477_ _3712_/Q place81/Z _2485_/S _3712_/D VDD VDD VSS VSS gf180mcu_fd_sc_mcu7t5v0__mux2_2
X_4147_ _4147_/D _4148_/RN _4147_/CLK _4147_/Q VDD VDD VSS VSS gf180mcu_fd_sc_mcu7t5v0__dffrnq_1
XFILLER_18_37 VDD VDD VSS VSS gf180mcu_fd_sc_mcu7t5v0__fillcap_64
XFILLER_28_348 VDD VDD VSS VSS gf180mcu_fd_sc_mcu7t5v0__fill_2
XFILLER_83_454 VDD VDD VSS VSS gf180mcu_fd_sc_mcu7t5v0__fill_2
X_4078_ _4078_/D _4157_/RN _4109_/CLK _4078_/Q VDD VDD VSS VSS gf180mcu_fd_sc_mcu7t5v0__dffrnq_1
X_3029_ _3958_/Q _4046_/Q _3041_/S _3958_/D VDD VDD VSS VSS gf180mcu_fd_sc_mcu7t5v0__mux2_2
XFILLER_83_487 VDD VDD VSS VSS gf180mcu_fd_sc_mcu7t5v0__fill_2
XFILLER_24_521 VDD VDD VSS VSS gf180mcu_fd_sc_mcu7t5v0__fillcap_4
XTAP_TAPCELL_ROW_104_1636 VDD VSS gf180mcu_fd_sc_mcu7t5v0__filltie
XFILLER_52_885 VDD VDD VSS VSS gf180mcu_fd_sc_mcu7t5v0__fillcap_4
Xclkload2 clkload2/I clkload2/ZN VDD VDD VSS VSS gf180mcu_fd_sc_mcu7t5v0__clkinv_12
XTAP_TAPCELL_ROW_115_1787 VDD VSS gf180mcu_fd_sc_mcu7t5v0__filltie
XTAP_TAPCELL_ROW_115_1776 VDD VSS gf180mcu_fd_sc_mcu7t5v0__filltie
XFILLER_106_854 VDD VDD VSS VSS gf180mcu_fd_sc_mcu7t5v0__fillcap_16
XFILLER_132_172 VDD VDD VSS VSS gf180mcu_fd_sc_mcu7t5v0__fillcap_32
XFILLER_79_749 VDD VDD VSS VSS gf180mcu_fd_sc_mcu7t5v0__fillcap_16
XFILLER_59_44 VDD VDD VSS VSS gf180mcu_fd_sc_mcu7t5v0__fillcap_16
XFILLER_59_88 VDD VDD VSS VSS gf180mcu_fd_sc_mcu7t5v0__fillcap_8
XFILLER_115_72 VDD VDD VSS VSS gf180mcu_fd_sc_mcu7t5v0__fillcap_64
XFILLER_90_925 VDD VDD VSS VSS gf180mcu_fd_sc_mcu7t5v0__fillcap_8
XFILLER_74_454 VDD VDD VSS VSS gf180mcu_fd_sc_mcu7t5v0__fill_1
XFILLER_28_860 VDD VDD VSS VSS gf180mcu_fd_sc_mcu7t5v0__fillcap_8
XTAP_TAPCELL_ROW_17_505 VDD VSS gf180mcu_fd_sc_mcu7t5v0__filltie
XTAP_TAPCELL_ROW_45_869 VDD VSS gf180mcu_fd_sc_mcu7t5v0__filltie
XFILLER_30_502 VDD VDD VSS VSS gf180mcu_fd_sc_mcu7t5v0__fillcap_16
XFILLER_30_524 VDD VDD VSS VSS gf180mcu_fd_sc_mcu7t5v0__fill_1
XFILLER_30_535 VDD VDD VSS VSS gf180mcu_fd_sc_mcu7t5v0__fill_2
X_2400_ _4068_/Q _3678_/Q _2412_/S _3678_/D VDD VDD VSS VSS gf180mcu_fd_sc_mcu7t5v0__mux2_2
XFILLER_112_802 VDD VDD VSS VSS gf180mcu_fd_sc_mcu7t5v0__fill_2
XFILLER_97_524 VDD VDD VSS VSS gf180mcu_fd_sc_mcu7t5v0__fillcap_16
XFILLER_123_194 VDD VDD VSS VSS gf180mcu_fd_sc_mcu7t5v0__fill_2
X_2262_ _3926_/Q place72/Z place63/Z _3958_/Q _3966_/Q place67/Z _2263_/I VDD VDD
+ VSS VSS gf180mcu_fd_sc_mcu7t5v0__aoi222_1
XTAP_TAPCELL_ROW_90_1459 VDD VSS gf180mcu_fd_sc_mcu7t5v0__filltie
X_4001_ _4001_/D input92/Z _4036_/CLK _4001_/Q VDD VDD VSS VSS gf180mcu_fd_sc_mcu7t5v0__dffrnq_1
X_2193_ _3375_/A2 _2192_/Z _2198_/A1 VDD VDD VSS VSS gf180mcu_fd_sc_mcu7t5v0__nand2_1
XFILLER_66_933 VDD VDD VSS VSS gf180mcu_fd_sc_mcu7t5v0__fill_1
XFILLER_53_605 VDD VDD VSS VSS gf180mcu_fd_sc_mcu7t5v0__fillcap_16
XFILLER_18_370 VDD VDD VSS VSS gf180mcu_fd_sc_mcu7t5v0__fillcap_8
XFILLER_52_104 VDD VDD VSS VSS gf180mcu_fd_sc_mcu7t5v0__fill_1
XFILLER_52_115 VDD VDD VSS VSS gf180mcu_fd_sc_mcu7t5v0__fill_2
XFILLER_65_476 VDD VDD VSS VSS gf180mcu_fd_sc_mcu7t5v0__fillcap_8
XFILLER_80_457 VDD VDD VSS VSS gf180mcu_fd_sc_mcu7t5v0__fillcap_8
XFILLER_34_885 VDD VDD VSS VSS gf180mcu_fd_sc_mcu7t5v0__fill_2
X_1977_ _1977_/A1 _1977_/A2 _1977_/ZN VDD VDD VSS VSS gf180mcu_fd_sc_mcu7t5v0__nand2_1
X_3716_ _3716_/D _3740_/CLK _3716_/Q VDD VDD VSS VSS gf180mcu_fd_sc_mcu7t5v0__dffq_1
XTAP_TAPCELL_ROW_132_2021 VDD VSS gf180mcu_fd_sc_mcu7t5v0__filltie
XTAP_TAPCELL_ROW_132_2010 VDD VSS gf180mcu_fd_sc_mcu7t5v0__filltie
X_3647_ _3647_/D _3755_/CLK _3647_/Q VDD VDD VSS VSS gf180mcu_fd_sc_mcu7t5v0__dffq_1
XFILLER_115_640 VDD VDD VSS VSS gf180mcu_fd_sc_mcu7t5v0__fill_2
X_3578_ _3574_/Z _3575_/Z _3576_/Z _3577_/Z place74/Z _4119_/Q _3578_/Z VDD VDD VSS
+ VSS gf180mcu_fd_sc_mcu7t5v0__mux4_1
XFILLER_130_621 VDD VDD VSS VSS gf180mcu_fd_sc_mcu7t5v0__fill_2
XFILLER_121_109 VDD VDD VSS VSS gf180mcu_fd_sc_mcu7t5v0__fillcap_8
XFILLER_29_36 VDD VDD VSS VSS gf180mcu_fd_sc_mcu7t5v0__fillcap_4
XFILLER_111_890 VDD VDD VSS VSS gf180mcu_fd_sc_mcu7t5v0__fill_1
XFILLER_84_752 VDD VDD VSS VSS gf180mcu_fd_sc_mcu7t5v0__fillcap_16
XFILLER_56_454 VDD VDD VSS VSS gf180mcu_fd_sc_mcu7t5v0__fill_1
XFILLER_83_273 VDD VDD VSS VSS gf180mcu_fd_sc_mcu7t5v0__fillcap_4
XTAP_TAPCELL_ROW_65_1130 VDD VSS gf180mcu_fd_sc_mcu7t5v0__filltie
XTAP_TAPCELL_ROW_42_828 VDD VSS gf180mcu_fd_sc_mcu7t5v0__filltie
XFILLER_129_209 VDD VDD VSS VSS gf180mcu_fd_sc_mcu7t5v0__fill_1
XFILLER_101_96 VDD VDD VSS VSS gf180mcu_fd_sc_mcu7t5v0__fill_1
XTAP_TAPCELL_ROW_117_1805 VDD VSS gf180mcu_fd_sc_mcu7t5v0__filltie
XTAP_TAPCELL_ROW_22_574 VDD VSS gf180mcu_fd_sc_mcu7t5v0__filltie
XFILLER_20_590 VDD VDD VSS VSS gf180mcu_fd_sc_mcu7t5v0__fill_1
XFILLER_106_684 VDD VDD VSS VSS gf180mcu_fd_sc_mcu7t5v0__fillcap_32
XTAP_TAPCELL_ROW_76_1270 VDD VSS gf180mcu_fd_sc_mcu7t5v0__filltie
XFILLER_94_527 VDD VDD VSS VSS gf180mcu_fd_sc_mcu7t5v0__fillcap_64
XFILLER_86_53 VDD VDD VSS VSS gf180mcu_fd_sc_mcu7t5v0__fillcap_32
XFILLER_121_698 VDD VDD VSS VSS gf180mcu_fd_sc_mcu7t5v0__fill_2
XFILLER_48_933 VDD VDD VSS VSS gf180mcu_fd_sc_mcu7t5v0__fill_1
XFILLER_66_229 VDD VDD VSS VSS gf180mcu_fd_sc_mcu7t5v0__fill_1
XTAP_TAPCELL_ROW_128_1956 VDD VSS gf180mcu_fd_sc_mcu7t5v0__filltie
XTAP_TAPCELL_ROW_128_1945 VDD VSS gf180mcu_fd_sc_mcu7t5v0__filltie
XFILLER_74_240 VDD VDD VSS VSS gf180mcu_fd_sc_mcu7t5v0__fillcap_4
XFILLER_90_733 VDD VDD VSS VSS gf180mcu_fd_sc_mcu7t5v0__fill_2
XFILLER_74_273 VDD VDD VSS VSS gf180mcu_fd_sc_mcu7t5v0__fill_1
XFILLER_35_627 VDD VDD VSS VSS gf180mcu_fd_sc_mcu7t5v0__fill_2
XFILLER_62_457 VDD VDD VSS VSS gf180mcu_fd_sc_mcu7t5v0__fillcap_32
XFILLER_31_800 VDD VDD VSS VSS gf180mcu_fd_sc_mcu7t5v0__fillcap_32
X_1900_ _4140_/Q _2058_/A1 VDD VDD VSS VSS gf180mcu_fd_sc_mcu7t5v0__clkinv_1
X_2880_ place87/Z _2900_/S _2881_/B VDD VDD VSS VSS gf180mcu_fd_sc_mcu7t5v0__nand2_1
XFILLER_70_490 VDD VDD VSS VSS gf180mcu_fd_sc_mcu7t5v0__fill_1
XFILLER_129_721 VDD VDD VSS VSS gf180mcu_fd_sc_mcu7t5v0__fillcap_8
X_1831_ _1835_/B _1935_/A1 _2013_/A4 _1935_/A4 _1837_/A3 VDD VDD VSS VSS gf180mcu_fd_sc_mcu7t5v0__nand4_1
XFILLER_30_387 VDD VDD VSS VSS gf180mcu_fd_sc_mcu7t5v0__fillcap_32
XFILLER_117_927 VDD VDD VSS VSS gf180mcu_fd_sc_mcu7t5v0__fillcap_4
XFILLER_7_594 VDD VDD VSS VSS gf180mcu_fd_sc_mcu7t5v0__fillcap_8
X_3501_ _2578_/Z _3508_/A2 _3501_/Z VDD VDD VSS VSS gf180mcu_fd_sc_mcu7t5v0__or2_2
X_3432_ _4101_/Q _3432_/A2 _3435_/A2 VDD VDD VSS VSS gf180mcu_fd_sc_mcu7t5v0__nand2_1
XFILLER_98_811 VDD VDD VSS VSS gf180mcu_fd_sc_mcu7t5v0__fill_2
X_3363_ _4082_/Q _4081_/Q _3365_/A2 VDD VDD VSS VSS gf180mcu_fd_sc_mcu7t5v0__nand2_1
XFILLER_111_142 VDD VDD VSS VSS gf180mcu_fd_sc_mcu7t5v0__fillcap_4
XFILLER_98_877 VDD VDD VSS VSS gf180mcu_fd_sc_mcu7t5v0__fillcap_32
X_3294_ _3288_/Z _3290_/Z _3294_/A3 _3294_/Z VDD VDD VSS VSS gf180mcu_fd_sc_mcu7t5v0__xor3_1
XFILLER_58_719 VDD VDD VSS VSS gf180mcu_fd_sc_mcu7t5v0__fill_1
X_2245_ _2245_/I _2245_/ZN VDD VDD VSS VSS gf180mcu_fd_sc_mcu7t5v0__inv_1
XFILLER_85_549 VDD VDD VSS VSS gf180mcu_fd_sc_mcu7t5v0__fillcap_8
X_2176_ _3375_/A2 _2175_/Z _2187_/A1 VDD VDD VSS VSS gf180mcu_fd_sc_mcu7t5v0__nand2_1
XFILLER_81_766 VDD VDD VSS VSS gf180mcu_fd_sc_mcu7t5v0__fillcap_4
XTAP_TAPCELL_ROW_0_269 VDD VSS gf180mcu_fd_sc_mcu7t5v0__filltie
XFILLER_81_788 VDD VDD VSS VSS gf180mcu_fd_sc_mcu7t5v0__fill_2
XFILLER_22_877 VDD VDD VSS VSS gf180mcu_fd_sc_mcu7t5v0__fillcap_16
XFILLER_31_26 VDD VDD VSS VSS gf180mcu_fd_sc_mcu7t5v0__fill_2
XTAP_TAPCELL_ROW_60_1060 VDD VSS gf180mcu_fd_sc_mcu7t5v0__filltie
XFILLER_119_264 VDD VDD VSS VSS gf180mcu_fd_sc_mcu7t5v0__fillcap_16
XTAP_TAPCELL_ROW_60_1071 VDD VSS gf180mcu_fd_sc_mcu7t5v0__filltie
XFILLER_123_908 VDD VDD VSS VSS gf180mcu_fd_sc_mcu7t5v0__fill_2
XPHY_EDGE_ROW_1_Right_1 VDD VSS gf180mcu_fd_sc_mcu7t5v0__endcap
XFILLER_103_610 VDD VDD VSS VSS gf180mcu_fd_sc_mcu7t5v0__fill_1
XFILLER_115_492 VDD VDD VSS VSS gf180mcu_fd_sc_mcu7t5v0__fillcap_64
XTAP_TAPCELL_ROW_112_1746 VDD VSS gf180mcu_fd_sc_mcu7t5v0__filltie
XFILLER_103_632 VDD VDD VSS VSS gf180mcu_fd_sc_mcu7t5v0__fillcap_64
XFILLER_103_621 VDD VDD VSS VSS gf180mcu_fd_sc_mcu7t5v0__fillcap_8
XFILLER_89_866 VDD VDD VSS VSS gf180mcu_fd_sc_mcu7t5v0__fill_2
Xinput126 hold197/Z _3148_/I1 VDD VDD VSS VSS gf180mcu_fd_sc_mcu7t5v0__dlyb_1
XFILLER_102_153 VDD VDD VSS VSS gf180mcu_fd_sc_mcu7t5v0__fillcap_16
Xinput115 hold205/Z _3127_/I1 VDD VDD VSS VSS gf180mcu_fd_sc_mcu7t5v0__dlyb_1
XFILLER_76_516 VDD VDD VSS VSS gf180mcu_fd_sc_mcu7t5v0__fill_1
Xinput104 hold230/Z _3092_/I1 VDD VDD VSS VSS gf180mcu_fd_sc_mcu7t5v0__dlyb_1
XFILLER_130_473 VDD VDD VSS VSS gf180mcu_fd_sc_mcu7t5v0__fillcap_4
XFILLER_88_387 VDD VDD VSS VSS gf180mcu_fd_sc_mcu7t5v0__fillcap_32
Xinput137 hold203/Z _3108_/I1 VDD VDD VSS VSS gf180mcu_fd_sc_mcu7t5v0__dlyb_1
XFILLER_84_560 VDD VDD VSS VSS gf180mcu_fd_sc_mcu7t5v0__fill_1
XTAP_TAPCELL_ROW_27_633 VDD VSS gf180mcu_fd_sc_mcu7t5v0__filltie
XFILLER_44_457 VDD VDD VSS VSS gf180mcu_fd_sc_mcu7t5v0__fillcap_16
XFILLER_44_435 VDD VDD VSS VSS gf180mcu_fd_sc_mcu7t5v0__fillcap_4
XFILLER_112_84 VDD VDD VSS VSS gf180mcu_fd_sc_mcu7t5v0__fillcap_16
XFILLER_60_917 VDD VDD VSS VSS gf180mcu_fd_sc_mcu7t5v0__fillcap_16
XTAP_TAPCELL_ROW_123_1886 VDD VSS gf180mcu_fd_sc_mcu7t5v0__filltie
XFILLER_13_844 VDD VDD VSS VSS gf180mcu_fd_sc_mcu7t5v0__fill_1
XTAP_TAPCELL_ROW_55_997 VDD VSS gf180mcu_fd_sc_mcu7t5v0__filltie
Xclkbuf_leaf_51_clk clkload0/I _4153_/CLK VDD VDD VSS VSS gf180mcu_fd_sc_mcu7t5v0__clkbuf_8
XFILLER_12_387 VDD VDD VSS VSS gf180mcu_fd_sc_mcu7t5v0__fill_2
XFILLER_8_314 VDD VDD VSS VSS gf180mcu_fd_sc_mcu7t5v0__fill_1
XFILLER_125_212 VDD VDD VSS VSS gf180mcu_fd_sc_mcu7t5v0__fillcap_4
XFILLER_4_531 VDD VDD VSS VSS gf180mcu_fd_sc_mcu7t5v0__fill_2
XFILLER_113_418 VDD VDD VSS VSS gf180mcu_fd_sc_mcu7t5v0__fill_2
XFILLER_106_481 VDD VDD VSS VSS gf180mcu_fd_sc_mcu7t5v0__fill_2
XFILLER_79_332 VDD VDD VSS VSS gf180mcu_fd_sc_mcu7t5v0__fill_2
XFILLER_4_597 VDD VDD VSS VSS gf180mcu_fd_sc_mcu7t5v0__fill_2
XFILLER_97_96 VDD VDD VSS VSS gf180mcu_fd_sc_mcu7t5v0__fillcap_4
XFILLER_95_858 VDD VDD VSS VSS gf180mcu_fd_sc_mcu7t5v0__fill_2
XTAP_TAPCELL_ROW_7_380 VDD VSS gf180mcu_fd_sc_mcu7t5v0__filltie
X_2030_ _4135_/Q _2030_/A2 _2030_/Z VDD VDD VSS VSS gf180mcu_fd_sc_mcu7t5v0__xor2_1
XFILLER_51_906 VDD VDD VSS VSS gf180mcu_fd_sc_mcu7t5v0__fillcap_4
X_3981_ _3981_/D _2279_/I _3981_/CLK _3981_/Q VDD VDD VSS VSS gf180mcu_fd_sc_mcu7t5v0__dffrnq_1
XFILLER_16_660 VDD VDD VSS VSS gf180mcu_fd_sc_mcu7t5v0__fillcap_4
XFILLER_22_107 VDD VDD VSS VSS gf180mcu_fd_sc_mcu7t5v0__fillcap_32
XFILLER_35_468 VDD VDD VSS VSS gf180mcu_fd_sc_mcu7t5v0__fillcap_16
XFILLER_50_416 VDD VDD VSS VSS gf180mcu_fd_sc_mcu7t5v0__fillcap_4
XFILLER_51_928 VDD VDD VSS VSS gf180mcu_fd_sc_mcu7t5v0__fillcap_4
XFILLER_63_766 VDD VDD VSS VSS gf180mcu_fd_sc_mcu7t5v0__fillcap_4
XFILLER_90_585 VDD VDD VSS VSS gf180mcu_fd_sc_mcu7t5v0__fillcap_8
Xclkbuf_leaf_42_clk clkload4/I _4072_/CLK VDD VDD VSS VSS gf180mcu_fd_sc_mcu7t5v0__clkbuf_8
XFILLER_87_2 VDD VDD VSS VSS gf180mcu_fd_sc_mcu7t5v0__fill_2
XFILLER_31_696 VDD VDD VSS VSS gf180mcu_fd_sc_mcu7t5v0__fillcap_4
X_2863_ place85/Z _3882_/Q _2867_/S _3882_/D VDD VDD VSS VSS gf180mcu_fd_sc_mcu7t5v0__mux2_2
XFILLER_129_562 VDD VDD VSS VSS gf180mcu_fd_sc_mcu7t5v0__fillcap_8
XFILLER_117_702 VDD VDD VSS VSS gf180mcu_fd_sc_mcu7t5v0__fillcap_32
XFILLER_7_72 VDD VDD VSS VSS gf180mcu_fd_sc_mcu7t5v0__fillcap_64
XFILLER_117_757 VDD VDD VSS VSS gf180mcu_fd_sc_mcu7t5v0__fillcap_8
XFILLER_132_716 VDD VDD VSS VSS gf180mcu_fd_sc_mcu7t5v0__fill_2
XFILLER_58_516 VDD VDD VSS VSS gf180mcu_fd_sc_mcu7t5v0__fill_2
XFILLER_58_527 VDD VDD VSS VSS gf180mcu_fd_sc_mcu7t5v0__fillcap_4
XFILLER_85_368 VDD VDD VSS VSS gf180mcu_fd_sc_mcu7t5v0__fillcap_4
X_3277_ _4148_/Q _4084_/Q _1952_/Z _3340_/A2 VDD VDD VSS VSS gf180mcu_fd_sc_mcu7t5v0__nand3_1
X_2228_ _3911_/Q place72/Z _2230_/A1 VDD VDD VSS VSS gf180mcu_fd_sc_mcu7t5v0__nand2_1
XFILLER_54_711 VDD VDD VSS VSS gf180mcu_fd_sc_mcu7t5v0__fillcap_16
XFILLER_26_37 VDD VDD VSS VSS gf180mcu_fd_sc_mcu7t5v0__fillcap_64
XFILLER_66_593 VDD VDD VSS VSS gf180mcu_fd_sc_mcu7t5v0__fill_2
X_2159_ _3744_/Q _3752_/Q _3640_/Q _3648_/Q place79/Z place78/Z _2159_/Z VDD VDD VSS
+ VSS gf180mcu_fd_sc_mcu7t5v0__mux4_1
XTAP_TAPCELL_ROW_24_603 VDD VSS gf180mcu_fd_sc_mcu7t5v0__filltie
XFILLER_26_457 VDD VDD VSS VSS gf180mcu_fd_sc_mcu7t5v0__fillcap_64
XFILLER_54_799 VDD VDD VSS VSS gf180mcu_fd_sc_mcu7t5v0__fillcap_4
Xclkbuf_leaf_33_clk clkload5/I _4094_/CLK VDD VDD VSS VSS gf180mcu_fd_sc_mcu7t5v0__clkbuf_8
XFILLER_22_641 VDD VDD VSS VSS gf180mcu_fd_sc_mcu7t5v0__fill_1
XTAP_TAPCELL_ROW_52_956 VDD VSS gf180mcu_fd_sc_mcu7t5v0__filltie
XTAP_TAPCELL_ROW_52_967 VDD VSS gf180mcu_fd_sc_mcu7t5v0__filltie
XFILLER_22_685 VDD VDD VSS VSS gf180mcu_fd_sc_mcu7t5v0__fillcap_32
XFILLER_108_724 VDD VDD VSS VSS gf180mcu_fd_sc_mcu7t5v0__fillcap_8
XFILLER_107_212 VDD VDD VSS VSS gf180mcu_fd_sc_mcu7t5v0__fillcap_32
XFILLER_108_757 VDD VDD VSS VSS gf180mcu_fd_sc_mcu7t5v0__fill_2
XPHY_EDGE_ROW_2_Left_135 VDD VSS gf180mcu_fd_sc_mcu7t5v0__endcap
XTAP_TAPCELL_ROW_73_1240 VDD VSS gf180mcu_fd_sc_mcu7t5v0__filltie
XFILLER_77_803 VDD VDD VSS VSS gf180mcu_fd_sc_mcu7t5v0__fillcap_32
XFILLER_49_505 VDD VDD VSS VSS gf180mcu_fd_sc_mcu7t5v0__fill_2
XFILLER_67_66 VDD VDD VSS VSS gf180mcu_fd_sc_mcu7t5v0__fillcap_4
XFILLER_67_88 VDD VDD VSS VSS gf180mcu_fd_sc_mcu7t5v0__fillcap_4
XTAP_TAPCELL_ROW_125_1915 VDD VSS gf180mcu_fd_sc_mcu7t5v0__filltie
XFILLER_92_839 VDD VDD VSS VSS gf180mcu_fd_sc_mcu7t5v0__fillcap_16
XFILLER_123_72 VDD VDD VSS VSS gf180mcu_fd_sc_mcu7t5v0__fillcap_64
XFILLER_83_76 VDD VDD VSS VSS gf180mcu_fd_sc_mcu7t5v0__fill_2
XFILLER_72_574 VDD VDD VSS VSS gf180mcu_fd_sc_mcu7t5v0__fillcap_16
XFILLER_33_928 VDD VDD VSS VSS gf180mcu_fd_sc_mcu7t5v0__fillcap_4
XFILLER_44_243 VDD VDD VSS VSS gf180mcu_fd_sc_mcu7t5v0__fill_2
XFILLER_44_265 VDD VDD VSS VSS gf180mcu_fd_sc_mcu7t5v0__fillcap_4
XFILLER_60_703 VDD VDD VSS VSS gf180mcu_fd_sc_mcu7t5v0__fill_2
XTAP_TAPCELL_ROW_84_1380 VDD VSS gf180mcu_fd_sc_mcu7t5v0__filltie
XFILLER_44_298 VDD VDD VSS VSS gf180mcu_fd_sc_mcu7t5v0__fillcap_4
Xclkbuf_leaf_24_clk clkload5/I _3978_/CLK VDD VDD VSS VSS gf180mcu_fd_sc_mcu7t5v0__clkbuf_8
XFILLER_16_81 VDD VDD VSS VSS gf180mcu_fd_sc_mcu7t5v0__fillcap_16
XFILLER_126_521 VDD VDD VSS VSS gf180mcu_fd_sc_mcu7t5v0__fillcap_4
XFILLER_8_177 VDD VDD VSS VSS gf180mcu_fd_sc_mcu7t5v0__fillcap_64
XFILLER_4_350 VDD VDD VSS VSS gf180mcu_fd_sc_mcu7t5v0__fill_2
X_3200_ _4039_/Q _4007_/Q _4129_/D _4039_/D VDD VDD VSS VSS gf180mcu_fd_sc_mcu7t5v0__mux2_2
X_3131_ _4006_/Q _3131_/I1 _3160_/S _4006_/D VDD VDD VSS VSS gf180mcu_fd_sc_mcu7t5v0__mux2_2
XTAP_TAPCELL_ROW_2_309 VDD VSS gf180mcu_fd_sc_mcu7t5v0__filltie
X_3062_ _3973_/Q _4124_/D _3065_/A2 VDD VDD VSS VSS gf180mcu_fd_sc_mcu7t5v0__nor2_1
XPHY_EDGE_ROW_66_Left_199 VDD VSS gf180mcu_fd_sc_mcu7t5v0__endcap
X_2013_ _2013_/A1 _1803_/Z _2013_/A3 _2013_/A4 _2013_/Z VDD VDD VSS VSS gf180mcu_fd_sc_mcu7t5v0__and4_1
XFILLER_94_198 VDD VDD VSS VSS gf180mcu_fd_sc_mcu7t5v0__fillcap_4
XFILLER_48_593 VDD VDD VSS VSS gf180mcu_fd_sc_mcu7t5v0__fill_2
XFILLER_24_928 VDD VDD VSS VSS gf180mcu_fd_sc_mcu7t5v0__fillcap_4
XFILLER_90_382 VDD VDD VSS VSS gf180mcu_fd_sc_mcu7t5v0__fill_2
X_3964_ _3964_/D _2279_/I _3981_/CLK _3964_/Q VDD VDD VSS VSS gf180mcu_fd_sc_mcu7t5v0__dffrnq_1
Xclkbuf_leaf_15_clk clkload1/I _4146_/CLK VDD VDD VSS VSS gf180mcu_fd_sc_mcu7t5v0__clkbuf_8
X_3895_ _3895_/D _4157_/RN _3946_/CLK _3895_/Q VDD VDD VSS VSS gf180mcu_fd_sc_mcu7t5v0__dffrnq_1
X_2846_ place85/Z _3874_/Q _2850_/S _3874_/D VDD VDD VSS VSS gf180mcu_fd_sc_mcu7t5v0__mux2_2
XFILLER_129_392 VDD VDD VSS VSS gf180mcu_fd_sc_mcu7t5v0__fillcap_8
XFILLER_132_546 VDD VDD VSS VSS gf180mcu_fd_sc_mcu7t5v0__fillcap_4
Xhold188 rst_n input92/I VDD VDD VSS VSS gf180mcu_fd_sc_mcu7t5v0__dlyc_1
XFILLER_59_814 VDD VDD VSS VSS gf180mcu_fd_sc_mcu7t5v0__fillcap_16
Xhold199 s_axi_awvalid hold199/Z VDD VDD VSS VSS gf180mcu_fd_sc_mcu7t5v0__dlyc_1
XFILLER_101_933 VDD VDD VSS VSS gf180mcu_fd_sc_mcu7t5v0__fill_1
X_3329_ _4082_/Q _4081_/Q _3334_/A3 _4083_/Q _3332_/B2 VDD VDD VSS VSS gf180mcu_fd_sc_mcu7t5v0__nor4_1
XFILLER_86_699 VDD VDD VSS VSS gf180mcu_fd_sc_mcu7t5v0__fill_2
XFILLER_73_316 VDD VDD VSS VSS gf180mcu_fd_sc_mcu7t5v0__fill_1
XFILLER_37_36 VDD VDD VSS VSS gf180mcu_fd_sc_mcu7t5v0__fill_2
XFILLER_58_379 VDD VDD VSS VSS gf180mcu_fd_sc_mcu7t5v0__fillcap_4
XFILLER_73_349 VDD VDD VSS VSS gf180mcu_fd_sc_mcu7t5v0__fill_1
XFILLER_27_722 VDD VDD VSS VSS gf180mcu_fd_sc_mcu7t5v0__fillcap_32
XFILLER_82_861 VDD VDD VSS VSS gf180mcu_fd_sc_mcu7t5v0__fillcap_8
XFILLER_15_928 VDD VDD VSS VSS gf180mcu_fd_sc_mcu7t5v0__fillcap_4
XFILLER_14_405 VDD VDD VSS VSS gf180mcu_fd_sc_mcu7t5v0__fillcap_32
XFILLER_26_243 VDD VDD VSS VSS gf180mcu_fd_sc_mcu7t5v0__fill_2
XTAP_TAPCELL_ROW_37_761 VDD VSS gf180mcu_fd_sc_mcu7t5v0__filltie
XTAP_TAPCELL_ROW_107_1678 VDD VSS gf180mcu_fd_sc_mcu7t5v0__filltie
XTAP_TAPCELL_ROW_37_772 VDD VSS gf180mcu_fd_sc_mcu7t5v0__filltie
XTAP_TAPCELL_ROW_120_1845 VDD VSS gf180mcu_fd_sc_mcu7t5v0__filltie
XFILLER_41_279 VDD VDD VSS VSS gf180mcu_fd_sc_mcu7t5v0__fill_1
XFILLER_10_655 VDD VDD VSS VSS gf180mcu_fd_sc_mcu7t5v0__fillcap_8
XFILLER_108_521 VDD VDD VSS VSS gf180mcu_fd_sc_mcu7t5v0__fillcap_4
XFILLER_5_125 VDD VDD VSS VSS gf180mcu_fd_sc_mcu7t5v0__fillcap_8
XTAP_TAPCELL_ROW_131_1985 VDD VSS gf180mcu_fd_sc_mcu7t5v0__filltie
XFILLER_77_699 VDD VDD VSS VSS gf180mcu_fd_sc_mcu7t5v0__fill_1
XFILLER_91_135 VDD VDD VSS VSS gf180mcu_fd_sc_mcu7t5v0__fillcap_4
XFILLER_18_733 VDD VDD VSS VSS gf180mcu_fd_sc_mcu7t5v0__fill_2
XFILLER_92_669 VDD VDD VSS VSS gf180mcu_fd_sc_mcu7t5v0__fill_1
XFILLER_27_80 VDD VDD VSS VSS gf180mcu_fd_sc_mcu7t5v0__fillcap_4
XFILLER_45_541 VDD VDD VSS VSS gf180mcu_fd_sc_mcu7t5v0__fillcap_16
XFILLER_17_276 VDD VDD VSS VSS gf180mcu_fd_sc_mcu7t5v0__fillcap_4
XFILLER_60_522 VDD VDD VSS VSS gf180mcu_fd_sc_mcu7t5v0__fill_2
XFILLER_72_360 VDD VDD VSS VSS gf180mcu_fd_sc_mcu7t5v0__fillcap_16
XTAP_TAPCELL_ROW_15_477 VDD VSS gf180mcu_fd_sc_mcu7t5v0__filltie
X_2700_ place88/Z _3807_/Q _2710_/S _3807_/D VDD VDD VSS VSS gf180mcu_fd_sc_mcu7t5v0__mux2_2
XFILLER_9_486 VDD VDD VSS VSS gf180mcu_fd_sc_mcu7t5v0__fillcap_4
X_3680_ _3680_/D _4108_/CLK _3680_/Q VDD VDD VSS VSS gf180mcu_fd_sc_mcu7t5v0__dffq_1
X_2562_ _3750_/Q _4068_/Q _2574_/S _3750_/D VDD VDD VSS VSS gf180mcu_fd_sc_mcu7t5v0__mux2_2
XFILLER_114_524 VDD VDD VSS VSS gf180mcu_fd_sc_mcu7t5v0__fill_1
XFILLER_88_909 VDD VDD VSS VSS gf180mcu_fd_sc_mcu7t5v0__fillcap_16
XFILLER_102_719 VDD VDD VSS VSS gf180mcu_fd_sc_mcu7t5v0__fillcap_16
XFILLER_87_419 VDD VDD VSS VSS gf180mcu_fd_sc_mcu7t5v0__fill_1
X_2493_ _3719_/Q _4069_/Q _2503_/S _3719_/D VDD VDD VSS VSS gf180mcu_fd_sc_mcu7t5v0__mux2_2
Xclkbuf_leaf_4_clk clkbuf_leaf_5_clk/I _3877_/CLK VDD VDD VSS VSS gf180mcu_fd_sc_mcu7t5v0__clkbuf_8
XFILLER_122_590 VDD VDD VSS VSS gf180mcu_fd_sc_mcu7t5v0__fillcap_4
XPHY_EDGE_ROW_74_Left_207 VDD VSS gf180mcu_fd_sc_mcu7t5v0__endcap
X_4163_ _4163_/D input92/Z _4163_/CLK _4163_/Q VDD VDD VSS VSS gf180mcu_fd_sc_mcu7t5v0__dffrnq_1
XFILLER_68_633 VDD VDD VSS VSS gf180mcu_fd_sc_mcu7t5v0__fill_2
XFILLER_95_452 VDD VDD VSS VSS gf180mcu_fd_sc_mcu7t5v0__fill_1
X_4094_ _4094_/D _2279_/I _4094_/CLK _4094_/Q VDD VDD VSS VSS gf180mcu_fd_sc_mcu7t5v0__dffrnq_1
XFILLER_28_519 VDD VDD VSS VSS gf180mcu_fd_sc_mcu7t5v0__fillcap_4
XFILLER_83_647 VDD VDD VSS VSS gf180mcu_fd_sc_mcu7t5v0__fill_2
XFILLER_49_891 VDD VDD VSS VSS gf180mcu_fd_sc_mcu7t5v0__fillcap_16
XFILLER_51_500 VDD VDD VSS VSS gf180mcu_fd_sc_mcu7t5v0__fillcap_4
XFILLER_63_382 VDD VDD VSS VSS gf180mcu_fd_sc_mcu7t5v0__fillcap_32
XTAP_TAPCELL_ROW_34_731 VDD VSS gf180mcu_fd_sc_mcu7t5v0__filltie
X_3947_ _3947_/D _4157_/RN _3975_/CLK _3947_/Q VDD VDD VSS VSS gf180mcu_fd_sc_mcu7t5v0__dffrnq_1
XPHY_EDGE_ROW_83_Left_216 VDD VSS gf180mcu_fd_sc_mcu7t5v0__endcap
X_3878_ _3878_/D _4057_/CLK _3878_/Q VDD VDD VSS VSS gf180mcu_fd_sc_mcu7t5v0__dffq_1
X_2829_ place85/Z _3866_/Q _2833_/S _3866_/D VDD VDD VSS VSS gf180mcu_fd_sc_mcu7t5v0__mux2_2
XTAP_TAPCELL_ROW_57_1021 VDD VSS gf180mcu_fd_sc_mcu7t5v0__filltie
XTAP_TAPCELL_ROW_57_1032 VDD VSS gf180mcu_fd_sc_mcu7t5v0__filltie
XFILLER_105_557 VDD VDD VSS VSS gf180mcu_fd_sc_mcu7t5v0__fill_2
XFILLER_132_376 VDD VDD VSS VSS gf180mcu_fd_sc_mcu7t5v0__fillcap_32
XPHY_EDGE_ROW_92_Left_225 VDD VSS gf180mcu_fd_sc_mcu7t5v0__endcap
XFILLER_59_622 VDD VDD VSS VSS gf180mcu_fd_sc_mcu7t5v0__fillcap_8
XPHY_EDGE_ROW_122_Right_122 VDD VSS gf180mcu_fd_sc_mcu7t5v0__endcap
XTAP_TAPCELL_ROW_109_1707 VDD VSS gf180mcu_fd_sc_mcu7t5v0__filltie
XFILLER_100_262 VDD VDD VSS VSS gf180mcu_fd_sc_mcu7t5v0__fillcap_4
XFILLER_86_452 VDD VDD VSS VSS gf180mcu_fd_sc_mcu7t5v0__fill_2
XFILLER_46_327 VDD VDD VSS VSS gf180mcu_fd_sc_mcu7t5v0__fill_1
XFILLER_64_45 VDD VDD VSS VSS gf180mcu_fd_sc_mcu7t5v0__fillcap_4
XFILLER_54_360 VDD VDD VSS VSS gf180mcu_fd_sc_mcu7t5v0__fillcap_16
XTAP_TAPCELL_ROW_68_1172 VDD VSS gf180mcu_fd_sc_mcu7t5v0__filltie
XFILLER_42_555 VDD VDD VSS VSS gf180mcu_fd_sc_mcu7t5v0__fill_1
XFILLER_14_279 VDD VDD VSS VSS gf180mcu_fd_sc_mcu7t5v0__fillcap_4
XFILLER_42_577 VDD VDD VSS VSS gf180mcu_fd_sc_mcu7t5v0__fillcap_16
XTAP_TAPCELL_ROW_12_436 VDD VSS gf180mcu_fd_sc_mcu7t5v0__filltie
XTAP_TAPCELL_ROW_12_447 VDD VSS gf180mcu_fd_sc_mcu7t5v0__filltie
XFILLER_108_384 VDD VDD VSS VSS gf180mcu_fd_sc_mcu7t5v0__fill_1
XFILLER_124_877 VDD VDD VSS VSS gf180mcu_fd_sc_mcu7t5v0__fillcap_16
XFILLER_69_419 VDD VDD VSS VSS gf180mcu_fd_sc_mcu7t5v0__fill_1
XFILLER_123_398 VDD VDD VSS VSS gf180mcu_fd_sc_mcu7t5v0__fillcap_16
Xclkbuf_3_7__f_clk clkbuf_0_clk/Z clkload6/I VDD VDD VSS VSS gf180mcu_fd_sc_mcu7t5v0__clkbuf_16
XFILLER_92_466 VDD VDD VSS VSS gf180mcu_fd_sc_mcu7t5v0__fill_1
XFILLER_18_574 VDD VDD VSS VSS gf180mcu_fd_sc_mcu7t5v0__fillcap_16
XFILLER_18_563 VDD VDD VSS VSS gf180mcu_fd_sc_mcu7t5v0__fill_2
XFILLER_61_842 VDD VDD VSS VSS gf180mcu_fd_sc_mcu7t5v0__fillcap_16
XFILLER_61_864 VDD VDD VSS VSS gf180mcu_fd_sc_mcu7t5v0__fill_1
X_3801_ _3801_/D _3806_/CLK _3801_/Q VDD VDD VSS VSS gf180mcu_fd_sc_mcu7t5v0__dffq_1
X_1993_ _1993_/A1 _1993_/A2 _1993_/B _1993_/C _1995_/A2 VDD VDD VSS VSS gf180mcu_fd_sc_mcu7t5v0__oai211_1
XFILLER_119_627 VDD VDD VSS VSS gf180mcu_fd_sc_mcu7t5v0__fill_2
X_3732_ _3732_/D _3732_/CLK _3732_/Q VDD VDD VSS VSS gf180mcu_fd_sc_mcu7t5v0__dffq_1
XTAP_TAPCELL_ROW_95_1519 VDD VSS gf180mcu_fd_sc_mcu7t5v0__filltie
Xclkload20 _3866_/CLK clkload20/ZN VDD VDD VSS VSS gf180mcu_fd_sc_mcu7t5v0__inv_1
X_3663_ _3663_/D _3750_/CLK _3663_/Q VDD VDD VSS VSS gf180mcu_fd_sc_mcu7t5v0__dffq_1
Xclkload53 _3733_/CLK clkload53/Z VDD VDD VSS VSS gf180mcu_fd_sc_mcu7t5v0__clkbuf_2
Xclkload31 _4127_/CLK clkload31/Z VDD VDD VSS VSS gf180mcu_fd_sc_mcu7t5v0__clkbuf_2
Xclkload42 _3732_/CLK clkload42/Z VDD VDD VSS VSS gf180mcu_fd_sc_mcu7t5v0__clkbuf_2
XFILLER_130_814 VDD VDD VSS VSS gf180mcu_fd_sc_mcu7t5v0__fillcap_4
XFILLER_114_387 VDD VDD VSS VSS gf180mcu_fd_sc_mcu7t5v0__fillcap_64
XFILLER_102_527 VDD VDD VSS VSS gf180mcu_fd_sc_mcu7t5v0__fillcap_16
X_4146_ _4146_/D _4148_/RN _4146_/CLK _4146_/Q VDD VDD VSS VSS gf180mcu_fd_sc_mcu7t5v0__dffrnq_1
XFILLER_29_806 VDD VDD VSS VSS gf180mcu_fd_sc_mcu7t5v0__fill_1
XFILLER_68_452 VDD VDD VSS VSS gf180mcu_fd_sc_mcu7t5v0__fill_2
XFILLER_95_293 VDD VDD VSS VSS gf180mcu_fd_sc_mcu7t5v0__fillcap_32
XFILLER_95_282 VDD VDD VSS VSS gf180mcu_fd_sc_mcu7t5v0__fillcap_4
XFILLER_83_422 VDD VDD VSS VSS gf180mcu_fd_sc_mcu7t5v0__fillcap_32
XFILLER_71_617 VDD VDD VSS VSS gf180mcu_fd_sc_mcu7t5v0__fillcap_8
X_4077_ _4077_/D input92/Z _4159_/CLK _4077_/Q VDD VDD VSS VSS gf180mcu_fd_sc_mcu7t5v0__dffsnq_1
XTAP_TAPCELL_ROW_104_1637 VDD VSS gf180mcu_fd_sc_mcu7t5v0__filltie
XFILLER_34_37 VDD VDD VSS VSS gf180mcu_fd_sc_mcu7t5v0__fillcap_64
XFILLER_24_588 VDD VDD VSS VSS gf180mcu_fd_sc_mcu7t5v0__fillcap_4
XFILLER_51_341 VDD VDD VSS VSS gf180mcu_fd_sc_mcu7t5v0__fillcap_8
Xclkload3 clkload3/I clkload3/ZN VDD VDD VSS VSS gf180mcu_fd_sc_mcu7t5v0__inv_4
XFILLER_124_107 VDD VDD VSS VSS gf180mcu_fd_sc_mcu7t5v0__fillcap_8
XFILLER_109_148 VDD VDD VSS VSS gf180mcu_fd_sc_mcu7t5v0__fill_1
XTAP_TAPCELL_ROW_115_1777 VDD VSS gf180mcu_fd_sc_mcu7t5v0__filltie
XFILLER_105_321 VDD VDD VSS VSS gf180mcu_fd_sc_mcu7t5v0__fillcap_8
XFILLER_121_836 VDD VDD VSS VSS gf180mcu_fd_sc_mcu7t5v0__fillcap_4
XFILLER_87_772 VDD VDD VSS VSS gf180mcu_fd_sc_mcu7t5v0__fillcap_64
XFILLER_75_912 VDD VDD VSS VSS gf180mcu_fd_sc_mcu7t5v0__fillcap_16
XFILLER_47_603 VDD VDD VSS VSS gf180mcu_fd_sc_mcu7t5v0__fillcap_16
XFILLER_59_452 VDD VDD VSS VSS gf180mcu_fd_sc_mcu7t5v0__fillcap_16
XFILLER_86_271 VDD VDD VSS VSS gf180mcu_fd_sc_mcu7t5v0__fillcap_4
XFILLER_74_411 VDD VDD VSS VSS gf180mcu_fd_sc_mcu7t5v0__fill_1
XFILLER_46_102 VDD VDD VSS VSS gf180mcu_fd_sc_mcu7t5v0__fill_2
XTAP_TAPCELL_ROW_17_506 VDD VSS gf180mcu_fd_sc_mcu7t5v0__filltie
XFILLER_28_872 VDD VDD VSS VSS gf180mcu_fd_sc_mcu7t5v0__fill_2
XFILLER_55_680 VDD VDD VSS VSS gf180mcu_fd_sc_mcu7t5v0__fillcap_16
XFILLER_43_842 VDD VDD VSS VSS gf180mcu_fd_sc_mcu7t5v0__fillcap_8
XFILLER_131_94 VDD VDD VSS VSS gf180mcu_fd_sc_mcu7t5v0__fill_1
XFILLER_11_772 VDD VDD VSS VSS gf180mcu_fd_sc_mcu7t5v0__fillcap_32
XFILLER_128_457 VDD VDD VSS VSS gf180mcu_fd_sc_mcu7t5v0__fillcap_4
XFILLER_10_282 VDD VDD VSS VSS gf180mcu_fd_sc_mcu7t5v0__fillcap_16
XFILLER_6_242 VDD VDD VSS VSS gf180mcu_fd_sc_mcu7t5v0__fill_2
X_2330_ place81/Z _3648_/Q _2338_/S _3648_/D VDD VDD VSS VSS gf180mcu_fd_sc_mcu7t5v0__mux2_2
X_2261_ _2261_/I _2261_/ZN VDD VDD VSS VSS gf180mcu_fd_sc_mcu7t5v0__inv_1
XFILLER_111_346 VDD VDD VSS VSS gf180mcu_fd_sc_mcu7t5v0__fillcap_4
XFILLER_111_368 VDD VDD VSS VSS gf180mcu_fd_sc_mcu7t5v0__fillcap_8
X_4000_ _4000_/D input92/Z _4036_/CLK _4000_/Q VDD VDD VSS VSS gf180mcu_fd_sc_mcu7t5v0__dffrnq_1
X_2192_ _2188_/Z _2189_/Z _2190_/Z _2191_/Z place77/Z _4094_/Q _2192_/Z VDD VDD VSS
+ VSS gf180mcu_fd_sc_mcu7t5v0__mux4_1
XFILLER_77_282 VDD VDD VSS VSS gf180mcu_fd_sc_mcu7t5v0__fillcap_64
XFILLER_65_422 VDD VDD VSS VSS gf180mcu_fd_sc_mcu7t5v0__fillcap_16
XFILLER_37_135 VDD VDD VSS VSS gf180mcu_fd_sc_mcu7t5v0__fillcap_4
XFILLER_92_263 VDD VDD VSS VSS gf180mcu_fd_sc_mcu7t5v0__fillcap_8
XFILLER_80_403 VDD VDD VSS VSS gf180mcu_fd_sc_mcu7t5v0__fillcap_4
XFILLER_65_488 VDD VDD VSS VSS gf180mcu_fd_sc_mcu7t5v0__fill_2
XFILLER_18_382 VDD VDD VSS VSS gf180mcu_fd_sc_mcu7t5v0__fill_2
XFILLER_33_352 VDD VDD VSS VSS gf180mcu_fd_sc_mcu7t5v0__fillcap_64
X_1976_ _3933_/Q _4124_/Q _3934_/Q _4125_/Q _1977_/A2 VDD VDD VSS VSS gf180mcu_fd_sc_mcu7t5v0__aoi22_1
XFILLER_21_558 VDD VDD VSS VSS gf180mcu_fd_sc_mcu7t5v0__fill_2
X_3715_ _3715_/D _3740_/CLK _3715_/Q VDD VDD VSS VSS gf180mcu_fd_sc_mcu7t5v0__dffq_1
XTAP_TAPCELL_ROW_132_2022 VDD VSS gf180mcu_fd_sc_mcu7t5v0__filltie
XTAP_TAPCELL_ROW_132_2011 VDD VSS gf180mcu_fd_sc_mcu7t5v0__filltie
XTAP_TAPCELL_ROW_132_2000 VDD VSS gf180mcu_fd_sc_mcu7t5v0__filltie
XFILLER_106_107 VDD VDD VSS VSS gf180mcu_fd_sc_mcu7t5v0__fillcap_64
X_3646_ _3646_/D _4157_/CLK _3646_/Q VDD VDD VSS VSS gf180mcu_fd_sc_mcu7t5v0__dffq_1
X_3577_ _3785_/Q _3793_/Q _3801_/Q _3809_/Q place76/Z place75/Z _3577_/Z VDD VDD VSS
+ VSS gf180mcu_fd_sc_mcu7t5v0__mux4_1
XFILLER_103_836 VDD VDD VSS VSS gf180mcu_fd_sc_mcu7t5v0__fillcap_4
X_2528_ _4069_/Q _3735_/Q _2538_/S _3735_/D VDD VDD VSS VSS gf180mcu_fd_sc_mcu7t5v0__mux2_2
XFILLER_57_912 VDD VDD VSS VSS gf180mcu_fd_sc_mcu7t5v0__fillcap_16
XFILLER_69_761 VDD VDD VSS VSS gf180mcu_fd_sc_mcu7t5v0__fillcap_8
XFILLER_69_772 VDD VDD VSS VSS gf180mcu_fd_sc_mcu7t5v0__fillcap_8
XFILLER_28_102 VDD VDD VSS VSS gf180mcu_fd_sc_mcu7t5v0__fill_2
XFILLER_83_241 VDD VDD VSS VSS gf180mcu_fd_sc_mcu7t5v0__fillcap_32
X_4129_ _4129_/D input92/Z _4129_/CLK _4129_/Q VDD VDD VSS VSS gf180mcu_fd_sc_mcu7t5v0__dffrnq_1
XFILLER_25_842 VDD VDD VSS VSS gf180mcu_fd_sc_mcu7t5v0__fillcap_8
XFILLER_45_69 VDD VDD VSS VSS gf180mcu_fd_sc_mcu7t5v0__fill_1
XTAP_TAPCELL_ROW_65_1131 VDD VSS gf180mcu_fd_sc_mcu7t5v0__filltie
XFILLER_25_875 VDD VDD VSS VSS gf180mcu_fd_sc_mcu7t5v0__fill_2
XTAP_TAPCELL_ROW_42_829 VDD VSS gf180mcu_fd_sc_mcu7t5v0__filltie
XFILLER_52_683 VDD VDD VSS VSS gf180mcu_fd_sc_mcu7t5v0__fillcap_8
XFILLER_61_68 VDD VDD VSS VSS gf180mcu_fd_sc_mcu7t5v0__fill_2
XTAP_TAPCELL_ROW_22_575 VDD VSS gf180mcu_fd_sc_mcu7t5v0__filltie
XTAP_TAPCELL_ROW_117_1806 VDD VSS gf180mcu_fd_sc_mcu7t5v0__filltie
XFILLER_117_2 VDD VDD VSS VSS gf180mcu_fd_sc_mcu7t5v0__fillcap_8
XFILLER_106_641 VDD VDD VSS VSS gf180mcu_fd_sc_mcu7t5v0__fill_2
XFILLER_105_162 VDD VDD VSS VSS gf180mcu_fd_sc_mcu7t5v0__fill_2
XTAP_TAPCELL_ROW_76_1271 VDD VSS gf180mcu_fd_sc_mcu7t5v0__filltie
XFILLER_59_260 VDD VDD VSS VSS gf180mcu_fd_sc_mcu7t5v0__fillcap_16
XFILLER_59_282 VDD VDD VSS VSS gf180mcu_fd_sc_mcu7t5v0__fill_2
XTAP_TAPCELL_ROW_128_1946 VDD VSS gf180mcu_fd_sc_mcu7t5v0__filltie
XFILLER_74_263 VDD VDD VSS VSS gf180mcu_fd_sc_mcu7t5v0__fillcap_8
XFILLER_47_488 VDD VDD VSS VSS gf180mcu_fd_sc_mcu7t5v0__fill_2
XFILLER_62_403 VDD VDD VSS VSS gf180mcu_fd_sc_mcu7t5v0__fillcap_8
XFILLER_15_352 VDD VDD VSS VSS gf180mcu_fd_sc_mcu7t5v0__fillcap_64
XFILLER_42_171 VDD VDD VSS VSS gf180mcu_fd_sc_mcu7t5v0__fillcap_4
XFILLER_43_694 VDD VDD VSS VSS gf180mcu_fd_sc_mcu7t5v0__fillcap_4
X_1830_ _1819_/Z _1820_/Z _1822_/Z _4144_/Q _1837_/A2 VDD VDD VSS VSS gf180mcu_fd_sc_mcu7t5v0__oai31_2
XFILLER_30_333 VDD VDD VSS VSS gf180mcu_fd_sc_mcu7t5v0__fillcap_8
XFILLER_42_193 VDD VDD VSS VSS gf180mcu_fd_sc_mcu7t5v0__fillcap_8
XFILLER_30_377 VDD VDD VSS VSS gf180mcu_fd_sc_mcu7t5v0__fillcap_8
XFILLER_128_243 VDD VDD VSS VSS gf180mcu_fd_sc_mcu7t5v0__fill_2
XFILLER_7_540 VDD VDD VSS VSS gf180mcu_fd_sc_mcu7t5v0__fill_2
X_3500_ _3500_/I _3508_/A2 VDD VDD VSS VSS gf180mcu_fd_sc_mcu7t5v0__clkinv_1
XFILLER_128_265 VDD VDD VSS VSS gf180mcu_fd_sc_mcu7t5v0__fillcap_4
XFILLER_7_562 VDD VDD VSS VSS gf180mcu_fd_sc_mcu7t5v0__fillcap_32
X_3431_ _3904_/Q _4099_/Q _3432_/A2 VDD VDD VSS VSS gf180mcu_fd_sc_mcu7t5v0__xnor2_1
X_3362_ _4082_/Q _3362_/A2 _3357_/Z _3362_/B _4082_/D VDD VDD VSS VSS gf180mcu_fd_sc_mcu7t5v0__oai31_2
XFILLER_112_644 VDD VDD VSS VSS gf180mcu_fd_sc_mcu7t5v0__fillcap_16
XFILLER_32_2 VDD VDD VSS VSS gf180mcu_fd_sc_mcu7t5v0__fillcap_32
X_2313_ _3641_/Q _4071_/Q _2319_/S _3641_/D VDD VDD VSS VSS gf180mcu_fd_sc_mcu7t5v0__mux2_2
X_3293_ place91/Z _3293_/A2 _3294_/A3 VDD VDD VSS VSS gf180mcu_fd_sc_mcu7t5v0__nand2_1
XFILLER_39_912 VDD VDD VSS VSS gf180mcu_fd_sc_mcu7t5v0__fillcap_16
X_2244_ _3949_/Q place63/Z place67/Z _3974_/Q _3917_/Q place72/Z _2245_/I VDD VDD
+ VSS VSS gf180mcu_fd_sc_mcu7t5v0__aoi222_1
XFILLER_112_699 VDD VDD VSS VSS gf180mcu_fd_sc_mcu7t5v0__fillcap_16
XFILLER_66_731 VDD VDD VSS VSS gf180mcu_fd_sc_mcu7t5v0__fillcap_4
XFILLER_111_198 VDD VDD VSS VSS gf180mcu_fd_sc_mcu7t5v0__fillcap_8
X_2175_ _2171_/Z _2172_/Z _2173_/Z _2174_/Z place77/Z _4094_/Q _2175_/Z VDD VDD VSS
+ VSS gf180mcu_fd_sc_mcu7t5v0__mux4_1
XFILLER_81_712 VDD VDD VSS VSS gf180mcu_fd_sc_mcu7t5v0__fill_1
XFILLER_65_252 VDD VDD VSS VSS gf180mcu_fd_sc_mcu7t5v0__fillcap_16
XFILLER_93_594 VDD VDD VSS VSS gf180mcu_fd_sc_mcu7t5v0__fillcap_8
XFILLER_25_138 VDD VDD VSS VSS gf180mcu_fd_sc_mcu7t5v0__fill_2
XFILLER_34_661 VDD VDD VSS VSS gf180mcu_fd_sc_mcu7t5v0__fillcap_4
XFILLER_53_458 VDD VDD VSS VSS gf180mcu_fd_sc_mcu7t5v0__fillcap_8
XFILLER_22_867 VDD VDD VSS VSS gf180mcu_fd_sc_mcu7t5v0__fillcap_8
XTAP_TAPCELL_ROW_60_1061 VDD VSS gf180mcu_fd_sc_mcu7t5v0__filltie
X_1959_ _3982_/Q _3083_/A1 VDD VDD VSS VSS gf180mcu_fd_sc_mcu7t5v0__clkinv_1
XTAP_TAPCELL_ROW_60_1072 VDD VSS gf180mcu_fd_sc_mcu7t5v0__filltie
X_3629_ _3629_/D _3968_/CLK _3629_/Q VDD VDD VSS VSS gf180mcu_fd_sc_mcu7t5v0__dffq_1
XFILLER_89_801 VDD VDD VSS VSS gf180mcu_fd_sc_mcu7t5v0__fillcap_4
XTAP_TAPCELL_ROW_112_1747 VDD VSS gf180mcu_fd_sc_mcu7t5v0__filltie
XTAP_TAPCELL_ROW_112_1736 VDD VSS gf180mcu_fd_sc_mcu7t5v0__filltie
XFILLER_89_834 VDD VDD VSS VSS gf180mcu_fd_sc_mcu7t5v0__fillcap_4
XFILLER_88_311 VDD VDD VSS VSS gf180mcu_fd_sc_mcu7t5v0__fillcap_4
Xinput127 hold211/Z _3150_/I1 VDD VDD VSS VSS gf180mcu_fd_sc_mcu7t5v0__dlyb_1
Xinput116 hold209/Z _3129_/I1 VDD VDD VSS VSS gf180mcu_fd_sc_mcu7t5v0__dlyb_1
Xinput105 hold194/Z _3094_/I1 VDD VDD VSS VSS gf180mcu_fd_sc_mcu7t5v0__dlyb_1
Xinput138 hold208/Z _3110_/I1 VDD VDD VSS VSS gf180mcu_fd_sc_mcu7t5v0__dlyb_1
XFILLER_29_422 VDD VDD VSS VSS gf180mcu_fd_sc_mcu7t5v0__fill_2
XFILLER_57_742 VDD VDD VSS VSS gf180mcu_fd_sc_mcu7t5v0__fill_2
XFILLER_84_550 VDD VDD VSS VSS gf180mcu_fd_sc_mcu7t5v0__fill_2
XFILLER_56_241 VDD VDD VSS VSS gf180mcu_fd_sc_mcu7t5v0__fillcap_4
XFILLER_112_52 VDD VDD VSS VSS gf180mcu_fd_sc_mcu7t5v0__fillcap_32
XTAP_TAPCELL_ROW_27_634 VDD VSS gf180mcu_fd_sc_mcu7t5v0__filltie
XFILLER_71_233 VDD VDD VSS VSS gf180mcu_fd_sc_mcu7t5v0__fillcap_16
XTAP_TAPCELL_ROW_123_1887 VDD VSS gf180mcu_fd_sc_mcu7t5v0__filltie
XFILLER_12_311 VDD VDD VSS VSS gf180mcu_fd_sc_mcu7t5v0__fillcap_4
XFILLER_24_171 VDD VDD VSS VSS gf180mcu_fd_sc_mcu7t5v0__fillcap_4
XFILLER_52_480 VDD VDD VSS VSS gf180mcu_fd_sc_mcu7t5v0__fillcap_8
XTAP_TAPCELL_ROW_55_998 VDD VSS gf180mcu_fd_sc_mcu7t5v0__filltie
XFILLER_12_333 VDD VDD VSS VSS gf180mcu_fd_sc_mcu7t5v0__fillcap_8
XFILLER_12_377 VDD VDD VSS VSS gf180mcu_fd_sc_mcu7t5v0__fillcap_8
XTAP_TAPCELL_ROW_78_1300 VDD VSS gf180mcu_fd_sc_mcu7t5v0__filltie
XFILLER_126_714 VDD VDD VSS VSS gf180mcu_fd_sc_mcu7t5v0__fillcap_4
XFILLER_126_769 VDD VDD VSS VSS gf180mcu_fd_sc_mcu7t5v0__fill_2
XFILLER_114_909 VDD VDD VSS VSS gf180mcu_fd_sc_mcu7t5v0__fillcap_16
XFILLER_4_521 VDD VDD VSS VSS gf180mcu_fd_sc_mcu7t5v0__fillcap_4
XFILLER_121_430 VDD VDD VSS VSS gf180mcu_fd_sc_mcu7t5v0__fillcap_4
XFILLER_121_485 VDD VDD VSS VSS gf180mcu_fd_sc_mcu7t5v0__fillcap_4
XFILLER_95_826 VDD VDD VSS VSS gf180mcu_fd_sc_mcu7t5v0__fillcap_8
XFILLER_94_314 VDD VDD VSS VSS gf180mcu_fd_sc_mcu7t5v0__fill_1
XTAP_TAPCELL_ROW_7_381 VDD VSS gf180mcu_fd_sc_mcu7t5v0__filltie
XTAP_TAPCELL_ROW_89_1440 VDD VSS gf180mcu_fd_sc_mcu7t5v0__filltie
XFILLER_48_731 VDD VDD VSS VSS gf180mcu_fd_sc_mcu7t5v0__fillcap_4
X_3980_ _3980_/D _2279_/I _3981_/CLK _3980_/Q VDD VDD VSS VSS gf180mcu_fd_sc_mcu7t5v0__dffrnq_1
X_2931_ _4032_/Q _3912_/Q _2972_/S _3912_/D VDD VDD VSS VSS gf180mcu_fd_sc_mcu7t5v0__mux2_2
XFILLER_90_597 VDD VDD VSS VSS gf180mcu_fd_sc_mcu7t5v0__fillcap_32
XFILLER_16_683 VDD VDD VSS VSS gf180mcu_fd_sc_mcu7t5v0__fillcap_4
XFILLER_31_620 VDD VDD VSS VSS gf180mcu_fd_sc_mcu7t5v0__fillcap_8
Xclkbuf_0_clk clk clkbuf_0_clk/Z VDD VDD VSS VSS gf180mcu_fd_sc_mcu7t5v0__clkbuf_16
X_1813_ _4147_/Q _1812_/Z place52/I VDD VDD VSS VSS gf180mcu_fd_sc_mcu7t5v0__nor2_2
X_2793_ place86/Z _3849_/Q _2799_/S _3849_/D VDD VDD VSS VSS gf180mcu_fd_sc_mcu7t5v0__mux2_2
XFILLER_30_174 VDD VDD VSS VSS gf180mcu_fd_sc_mcu7t5v0__fill_1
XFILLER_8_871 VDD VDD VSS VSS gf180mcu_fd_sc_mcu7t5v0__fillcap_4
XFILLER_117_769 VDD VDD VSS VSS gf180mcu_fd_sc_mcu7t5v0__fill_1
XFILLER_116_235 VDD VDD VSS VSS gf180mcu_fd_sc_mcu7t5v0__fillcap_8
XFILLER_105_909 VDD VDD VSS VSS gf180mcu_fd_sc_mcu7t5v0__fill_1
XFILLER_104_419 VDD VDD VSS VSS gf180mcu_fd_sc_mcu7t5v0__fillcap_16
X_3414_ _3414_/A1 _3413_/Z _4098_/D VDD VDD VSS VSS gf180mcu_fd_sc_mcu7t5v0__xor2_1
XPHY_EDGE_ROW_15_Right_15 VDD VSS gf180mcu_fd_sc_mcu7t5v0__endcap
XFILLER_112_441 VDD VDD VSS VSS gf180mcu_fd_sc_mcu7t5v0__fill_2
XFILLER_98_653 VDD VDD VSS VSS gf180mcu_fd_sc_mcu7t5v0__fillcap_8
X_3345_ _3902_/Q _3345_/A2 _4078_/D VDD VDD VSS VSS gf180mcu_fd_sc_mcu7t5v0__and2_1
X_3276_ _3263_/Z _3276_/A2 _3276_/B _4064_/D VDD VDD VSS VSS gf180mcu_fd_sc_mcu7t5v0__oai21_2
X_2227_ _2227_/A1 _2227_/A2 _2227_/ZN VDD VDD VSS VSS gf180mcu_fd_sc_mcu7t5v0__nand2_1
XFILLER_85_336 VDD VDD VSS VSS gf180mcu_fd_sc_mcu7t5v0__fill_2
X_2158_ _3712_/Q _3720_/Q _3728_/Q _3736_/Q place79/Z place78/Z _2158_/Z VDD VDD VSS
+ VSS gf180mcu_fd_sc_mcu7t5v0__mux4_1
X_2089_ _2089_/A1 _2079_/Z _2095_/A2 VDD VDD VSS VSS gf180mcu_fd_sc_mcu7t5v0__nor2_1
XPHY_EDGE_ROW_24_Right_24 VDD VSS gf180mcu_fd_sc_mcu7t5v0__endcap
XFILLER_41_406 VDD VDD VSS VSS gf180mcu_fd_sc_mcu7t5v0__fillcap_8
XFILLER_42_929 VDD VDD VSS VSS gf180mcu_fd_sc_mcu7t5v0__fillcap_4
XTAP_TAPCELL_ROW_24_604 VDD VSS gf180mcu_fd_sc_mcu7t5v0__filltie
XTAP_TAPCELL_ROW_52_957 VDD VSS gf180mcu_fd_sc_mcu7t5v0__filltie
XTAP_TAPCELL_ROW_52_968 VDD VSS gf180mcu_fd_sc_mcu7t5v0__filltie
XFILLER_10_804 VDD VDD VSS VSS gf180mcu_fd_sc_mcu7t5v0__fill_1
XFILLER_22_675 VDD VDD VSS VSS gf180mcu_fd_sc_mcu7t5v0__fill_2
XFILLER_42_37 VDD VDD VSS VSS gf180mcu_fd_sc_mcu7t5v0__fillcap_16
XFILLER_5_318 VDD VDD VSS VSS gf180mcu_fd_sc_mcu7t5v0__fill_2
XPHY_EDGE_ROW_33_Right_33 VDD VSS gf180mcu_fd_sc_mcu7t5v0__endcap
XFILLER_104_931 VDD VDD VSS VSS gf180mcu_fd_sc_mcu7t5v0__fill_2
XTAP_TAPCELL_ROW_73_1241 VDD VSS gf180mcu_fd_sc_mcu7t5v0__filltie
XTAP_TAPCELL_ROW_73_1230 VDD VSS gf180mcu_fd_sc_mcu7t5v0__filltie
XFILLER_107_63 VDD VDD VSS VSS gf180mcu_fd_sc_mcu7t5v0__fillcap_4
XFILLER_89_664 VDD VDD VSS VSS gf180mcu_fd_sc_mcu7t5v0__fill_2
XFILLER_131_772 VDD VDD VSS VSS gf180mcu_fd_sc_mcu7t5v0__fillcap_16
XFILLER_89_697 VDD VDD VSS VSS gf180mcu_fd_sc_mcu7t5v0__fill_2
XFILLER_92_807 VDD VDD VSS VSS gf180mcu_fd_sc_mcu7t5v0__fillcap_32
XTAP_TAPCELL_ROW_4_340 VDD VSS gf180mcu_fd_sc_mcu7t5v0__filltie
XTAP_TAPCELL_ROW_125_1916 VDD VSS gf180mcu_fd_sc_mcu7t5v0__filltie
XTAP_TAPCELL_ROW_125_1905 VDD VSS gf180mcu_fd_sc_mcu7t5v0__filltie
XFILLER_64_509 VDD VDD VSS VSS gf180mcu_fd_sc_mcu7t5v0__fill_1
XPHY_EDGE_ROW_42_Right_42 VDD VSS gf180mcu_fd_sc_mcu7t5v0__endcap
XPHY_EDGE_ROW_103_Left_236 VDD VSS gf180mcu_fd_sc_mcu7t5v0__endcap
XFILLER_83_66 VDD VDD VSS VSS gf180mcu_fd_sc_mcu7t5v0__fillcap_4
XFILLER_72_542 VDD VDD VSS VSS gf180mcu_fd_sc_mcu7t5v0__fillcap_32
XFILLER_33_907 VDD VDD VSS VSS gf180mcu_fd_sc_mcu7t5v0__fill_2
XFILLER_72_597 VDD VDD VSS VSS gf180mcu_fd_sc_mcu7t5v0__fillcap_64
XFILLER_60_737 VDD VDD VSS VSS gf180mcu_fd_sc_mcu7t5v0__fillcap_8
XTAP_TAPCELL_ROW_84_1381 VDD VSS gf180mcu_fd_sc_mcu7t5v0__filltie
XFILLER_13_664 VDD VDD VSS VSS gf180mcu_fd_sc_mcu7t5v0__fillcap_16
XFILLER_12_174 VDD VDD VSS VSS gf180mcu_fd_sc_mcu7t5v0__fill_1
XPHY_EDGE_ROW_51_Right_51 VDD VSS gf180mcu_fd_sc_mcu7t5v0__endcap
XPHY_EDGE_ROW_112_Left_245 VDD VSS gf180mcu_fd_sc_mcu7t5v0__endcap
XFILLER_126_577 VDD VDD VSS VSS gf180mcu_fd_sc_mcu7t5v0__fill_2
XFILLER_99_406 VDD VDD VSS VSS gf180mcu_fd_sc_mcu7t5v0__fillcap_8
XFILLER_126_599 VDD VDD VSS VSS gf180mcu_fd_sc_mcu7t5v0__fill_1
XFILLER_4_384 VDD VDD VSS VSS gf180mcu_fd_sc_mcu7t5v0__fill_1
XFILLER_4_395 VDD VDD VSS VSS gf180mcu_fd_sc_mcu7t5v0__fill_2
XFILLER_94_100 VDD VDD VSS VSS gf180mcu_fd_sc_mcu7t5v0__fillcap_4
XFILLER_121_282 VDD VDD VSS VSS gf180mcu_fd_sc_mcu7t5v0__fillcap_32
XFILLER_83_807 VDD VDD VSS VSS gf180mcu_fd_sc_mcu7t5v0__fill_1
XFILLER_82_317 VDD VDD VSS VSS gf180mcu_fd_sc_mcu7t5v0__fillcap_16
XFILLER_48_561 VDD VDD VSS VSS gf180mcu_fd_sc_mcu7t5v0__fillcap_32
XPHY_EDGE_ROW_60_Right_60 VDD VSS gf180mcu_fd_sc_mcu7t5v0__endcap
XPHY_EDGE_ROW_121_Left_254 VDD VSS gf180mcu_fd_sc_mcu7t5v0__endcap
X_3963_ _3963_/D _2279_/I _4128_/CLK _3963_/Q VDD VDD VSS VSS gf180mcu_fd_sc_mcu7t5v0__dffrnq_1
XFILLER_50_247 VDD VDD VSS VSS gf180mcu_fd_sc_mcu7t5v0__fillcap_64
X_3894_ _3894_/D _4157_/RN _3946_/CLK _3894_/Q VDD VDD VSS VSS gf180mcu_fd_sc_mcu7t5v0__dffrnq_1
X_2914_ place87/Z _3904_/Q _2972_/S _3904_/D VDD VDD VSS VSS gf180mcu_fd_sc_mcu7t5v0__mux2_2
XPHY_EDGE_ROW_130_Left_263 VDD VSS gf180mcu_fd_sc_mcu7t5v0__endcap
XFILLER_129_360 VDD VDD VSS VSS gf180mcu_fd_sc_mcu7t5v0__fillcap_32
XFILLER_128_18 VDD VDD VSS VSS gf180mcu_fd_sc_mcu7t5v0__fill_1
XFILLER_117_522 VDD VDD VSS VSS gf180mcu_fd_sc_mcu7t5v0__fill_1
X_2776_ place86/Z _3841_/Q _2782_/S _3841_/D VDD VDD VSS VSS gf180mcu_fd_sc_mcu7t5v0__mux2_2
XFILLER_132_503 VDD VDD VSS VSS gf180mcu_fd_sc_mcu7t5v0__fillcap_4
XPHY_EDGE_ROW_103_Right_103 VDD VSS gf180mcu_fd_sc_mcu7t5v0__endcap
Xhold189 s_axi_wvalid hold189/Z VDD VDD VSS VSS gf180mcu_fd_sc_mcu7t5v0__dlyc_1
X_3328_ _4084_/Q _3334_/A3 VDD VDD VSS VSS gf180mcu_fd_sc_mcu7t5v0__clkinv_1
XFILLER_58_314 VDD VDD VSS VSS gf180mcu_fd_sc_mcu7t5v0__fill_1
XFILLER_98_494 VDD VDD VSS VSS gf180mcu_fd_sc_mcu7t5v0__fillcap_16
XFILLER_86_667 VDD VDD VSS VSS gf180mcu_fd_sc_mcu7t5v0__fillcap_32
XFILLER_74_807 VDD VDD VSS VSS gf180mcu_fd_sc_mcu7t5v0__fillcap_64
X_3259_ _4064_/Q _3626_/A2 VDD VDD VSS VSS gf180mcu_fd_sc_mcu7t5v0__clkinv_1
XFILLER_39_572 VDD VDD VSS VSS gf180mcu_fd_sc_mcu7t5v0__fillcap_32
XFILLER_82_873 VDD VDD VSS VSS gf180mcu_fd_sc_mcu7t5v0__fill_2
XTAP_TAPCELL_ROW_107_1679 VDD VSS gf180mcu_fd_sc_mcu7t5v0__filltie
XTAP_TAPCELL_ROW_37_762 VDD VSS gf180mcu_fd_sc_mcu7t5v0__filltie
XTAP_TAPCELL_ROW_37_773 VDD VSS gf180mcu_fd_sc_mcu7t5v0__filltie
XFILLER_42_737 VDD VDD VSS VSS gf180mcu_fd_sc_mcu7t5v0__fillcap_64
XFILLER_54_575 VDD VDD VSS VSS gf180mcu_fd_sc_mcu7t5v0__fillcap_8
XFILLER_54_597 VDD VDD VSS VSS gf180mcu_fd_sc_mcu7t5v0__fillcap_32
XTAP_TAPCELL_ROW_120_1846 VDD VSS gf180mcu_fd_sc_mcu7t5v0__filltie
XFILLER_10_678 VDD VDD VSS VSS gf180mcu_fd_sc_mcu7t5v0__fill_2
XFILLER_5_137 VDD VDD VSS VSS gf180mcu_fd_sc_mcu7t5v0__fill_2
XFILLER_5_104 VDD VDD VSS VSS gf180mcu_fd_sc_mcu7t5v0__fill_1
XTAP_TAPCELL_ROW_131_1986 VDD VSS gf180mcu_fd_sc_mcu7t5v0__filltie
XFILLER_110_219 VDD VDD VSS VSS gf180mcu_fd_sc_mcu7t5v0__fillcap_16
XFILLER_104_783 VDD VDD VSS VSS gf180mcu_fd_sc_mcu7t5v0__fillcap_16
XFILLER_77_623 VDD VDD VSS VSS gf180mcu_fd_sc_mcu7t5v0__fillcap_4
XFILLER_78_99 VDD VDD VSS VSS gf180mcu_fd_sc_mcu7t5v0__fillcap_4
XFILLER_2_877 VDD VDD VSS VSS gf180mcu_fd_sc_mcu7t5v0__fillcap_32
XFILLER_103_282 VDD VDD VSS VSS gf180mcu_fd_sc_mcu7t5v0__fillcap_32
XFILLER_18_701 VDD VDD VSS VSS gf180mcu_fd_sc_mcu7t5v0__fillcap_32
XFILLER_64_317 VDD VDD VSS VSS gf180mcu_fd_sc_mcu7t5v0__fillcap_8
XTAP_TAPCELL_ROW_86_1410 VDD VSS gf180mcu_fd_sc_mcu7t5v0__filltie
XFILLER_76_177 VDD VDD VSS VSS gf180mcu_fd_sc_mcu7t5v0__fillcap_64
XFILLER_32_247 VDD VDD VSS VSS gf180mcu_fd_sc_mcu7t5v0__fillcap_16
XTAP_TAPCELL_ROW_15_478 VDD VSS gf180mcu_fd_sc_mcu7t5v0__filltie
X_2630_ place87/Z _3776_/Q _2638_/S _3776_/D VDD VDD VSS VSS gf180mcu_fd_sc_mcu7t5v0__mux2_2
XFILLER_127_842 VDD VDD VSS VSS gf180mcu_fd_sc_mcu7t5v0__fillcap_64
XTAP_TAPCELL_ROW_97_1550 VDD VSS gf180mcu_fd_sc_mcu7t5v0__filltie
XFILLER_4_41 VDD VDD VSS VSS gf180mcu_fd_sc_mcu7t5v0__fill_2
XFILLER_4_85 VDD VDD VSS VSS gf180mcu_fd_sc_mcu7t5v0__fillcap_16
X_4162_ _4162_/D input92/Z _4163_/CLK _4162_/Q VDD VDD VSS VSS gf180mcu_fd_sc_mcu7t5v0__dffrnq_1
X_4093_ _4093_/D _2279_/I _4126_/CLK _4093_/Q VDD VDD VSS VSS gf180mcu_fd_sc_mcu7t5v0__dffrnq_1
XFILLER_68_667 VDD VDD VSS VSS gf180mcu_fd_sc_mcu7t5v0__fillcap_8
XFILLER_83_626 VDD VDD VSS VSS gf180mcu_fd_sc_mcu7t5v0__fillcap_4
XFILLER_82_169 VDD VDD VSS VSS gf180mcu_fd_sc_mcu7t5v0__fillcap_4
XFILLER_91_692 VDD VDD VSS VSS gf180mcu_fd_sc_mcu7t5v0__fillcap_8
XTAP_TAPCELL_ROW_34_732 VDD VSS gf180mcu_fd_sc_mcu7t5v0__filltie
X_3946_ _3946_/D _4157_/RN _3946_/CLK _3946_/Q VDD VDD VSS VSS gf180mcu_fd_sc_mcu7t5v0__dffrnq_1
XFILLER_51_578 VDD VDD VSS VSS gf180mcu_fd_sc_mcu7t5v0__fillcap_4
X_3877_ _3877_/D _3877_/CLK _3877_/Q VDD VDD VSS VSS gf180mcu_fd_sc_mcu7t5v0__dffq_1
XFILLER_117_352 VDD VDD VSS VSS gf180mcu_fd_sc_mcu7t5v0__fillcap_64
XFILLER_2_107 VDD VDD VSS VSS gf180mcu_fd_sc_mcu7t5v0__fillcap_64
XTAP_TAPCELL_ROW_57_1022 VDD VSS gf180mcu_fd_sc_mcu7t5v0__filltie
XTAP_TAPCELL_ROW_57_1033 VDD VSS gf180mcu_fd_sc_mcu7t5v0__filltie
XFILLER_87_932 VDD VDD VSS VSS gf180mcu_fd_sc_mcu7t5v0__fill_2
XTAP_TAPCELL_ROW_70_1200 VDD VSS gf180mcu_fd_sc_mcu7t5v0__filltie
XFILLER_98_280 VDD VDD VSS VSS gf180mcu_fd_sc_mcu7t5v0__fill_2
XFILLER_58_111 VDD VDD VSS VSS gf180mcu_fd_sc_mcu7t5v0__fill_2
XTAP_TAPCELL_ROW_109_1708 VDD VSS gf180mcu_fd_sc_mcu7t5v0__filltie
XFILLER_73_125 VDD VDD VSS VSS gf180mcu_fd_sc_mcu7t5v0__fillcap_8
XFILLER_46_317 VDD VDD VSS VSS gf180mcu_fd_sc_mcu7t5v0__fillcap_8
XFILLER_58_177 VDD VDD VSS VSS gf180mcu_fd_sc_mcu7t5v0__fillcap_16
XFILLER_73_158 VDD VDD VSS VSS gf180mcu_fd_sc_mcu7t5v0__fillcap_8
XFILLER_15_726 VDD VDD VSS VSS gf180mcu_fd_sc_mcu7t5v0__fill_2
XFILLER_27_586 VDD VDD VSS VSS gf180mcu_fd_sc_mcu7t5v0__fillcap_4
XTAP_TAPCELL_ROW_68_1173 VDD VSS gf180mcu_fd_sc_mcu7t5v0__filltie
XFILLER_14_247 VDD VDD VSS VSS gf180mcu_fd_sc_mcu7t5v0__fillcap_32
XTAP_TAPCELL_ROW_81_1340 VDD VSS gf180mcu_fd_sc_mcu7t5v0__filltie
XFILLER_11_932 VDD VDD VSS VSS gf180mcu_fd_sc_mcu7t5v0__fill_2
XTAP_TAPCELL_ROW_12_448 VDD VSS gf180mcu_fd_sc_mcu7t5v0__filltie
XTAP_TAPCELL_ROW_12_437 VDD VSS gf180mcu_fd_sc_mcu7t5v0__filltie
XFILLER_10_442 VDD VDD VSS VSS gf180mcu_fd_sc_mcu7t5v0__fillcap_8
XFILLER_109_831 VDD VDD VSS VSS gf180mcu_fd_sc_mcu7t5v0__fillcap_8
XFILLER_13_72 VDD VDD VSS VSS gf180mcu_fd_sc_mcu7t5v0__fill_2
XFILLER_6_457 VDD VDD VSS VSS gf180mcu_fd_sc_mcu7t5v0__fillcap_16
XFILLER_124_823 VDD VDD VSS VSS gf180mcu_fd_sc_mcu7t5v0__fillcap_4
XFILLER_108_374 VDD VDD VSS VSS gf180mcu_fd_sc_mcu7t5v0__fillcap_8
XFILLER_108_396 VDD VDD VSS VSS gf180mcu_fd_sc_mcu7t5v0__fill_2
XFILLER_97_718 VDD VDD VSS VSS gf180mcu_fd_sc_mcu7t5v0__fillcap_4
XFILLER_96_217 VDD VDD VSS VSS gf180mcu_fd_sc_mcu7t5v0__fill_2
XTAP_TAPCELL_ROW_92_1480 VDD VSS gf180mcu_fd_sc_mcu7t5v0__filltie
XFILLER_104_591 VDD VDD VSS VSS gf180mcu_fd_sc_mcu7t5v0__fillcap_4
XFILLER_78_932 VDD VDD VSS VSS gf180mcu_fd_sc_mcu7t5v0__fill_2
XFILLER_65_626 VDD VDD VSS VSS gf180mcu_fd_sc_mcu7t5v0__fillcap_4
XFILLER_18_597 VDD VDD VSS VSS gf180mcu_fd_sc_mcu7t5v0__fillcap_64
X_3800_ _3800_/D _4129_/CLK _3800_/Q VDD VDD VSS VSS gf180mcu_fd_sc_mcu7t5v0__dffq_1
XFILLER_33_556 VDD VDD VSS VSS gf180mcu_fd_sc_mcu7t5v0__fillcap_4
X_1992_ _3394_/A3 _1992_/A2 _1993_/B VDD VDD VSS VSS gf180mcu_fd_sc_mcu7t5v0__nand2_1
X_3731_ _3731_/D _3740_/CLK _3731_/Q VDD VDD VSS VSS gf180mcu_fd_sc_mcu7t5v0__dffq_1
X_3662_ _3662_/D _4167_/CLK _3662_/Q VDD VDD VSS VSS gf180mcu_fd_sc_mcu7t5v0__dffq_1
Xclkload10 _4023_/CLK clkload10/ZN VDD VDD VSS VSS gf180mcu_fd_sc_mcu7t5v0__clkinv_2
Xclkload21 _4057_/CLK clkload21/ZN VDD VDD VSS VSS gf180mcu_fd_sc_mcu7t5v0__clkinv_1
Xclkload43 _4072_/CLK clkload43/Z VDD VDD VSS VSS gf180mcu_fd_sc_mcu7t5v0__clkbuf_8
X_3593_ _3592_/Z _4155_/Q _3600_/S _4155_/D VDD VDD VSS VSS gf180mcu_fd_sc_mcu7t5v0__mux2_2
Xclkload32 _4157_/CLK clkload32/Z VDD VDD VSS VSS gf180mcu_fd_sc_mcu7t5v0__clkbuf_2
X_2613_ place86/Z _3769_/Q _2619_/S _3769_/D VDD VDD VSS VSS gf180mcu_fd_sc_mcu7t5v0__mux2_2
XFILLER_127_694 VDD VDD VSS VSS gf180mcu_fd_sc_mcu7t5v0__fillcap_4
XFILLER_126_171 VDD VDD VSS VSS gf180mcu_fd_sc_mcu7t5v0__fillcap_4
XFILLER_114_311 VDD VDD VSS VSS gf180mcu_fd_sc_mcu7t5v0__fillcap_4
Xclkload54 _3738_/CLK clkload54/Z VDD VDD VSS VSS gf180mcu_fd_sc_mcu7t5v0__clkbuf_2
X_2544_ _3742_/Q _4068_/Q _2556_/S _3742_/D VDD VDD VSS VSS gf180mcu_fd_sc_mcu7t5v0__mux2_2
XFILLER_130_804 VDD VDD VSS VSS gf180mcu_fd_sc_mcu7t5v0__fill_1
XFILLER_114_355 VDD VDD VSS VSS gf180mcu_fd_sc_mcu7t5v0__fillcap_4
X_2475_ _3711_/Q _4069_/Q _2485_/S _3711_/D VDD VDD VSS VSS gf180mcu_fd_sc_mcu7t5v0__mux2_2
XFILLER_69_932 VDD VDD VSS VSS gf180mcu_fd_sc_mcu7t5v0__fill_2
X_4145_ _4145_/D _4148_/RN _4145_/CLK _4145_/Q VDD VDD VSS VSS gf180mcu_fd_sc_mcu7t5v0__dffrnq_1
XFILLER_96_773 VDD VDD VSS VSS gf180mcu_fd_sc_mcu7t5v0__fillcap_32
XFILLER_83_401 VDD VDD VSS VSS gf180mcu_fd_sc_mcu7t5v0__fillcap_4
X_4076_ _4076_/D input92/Z _4076_/CLK _4076_/Q VDD VDD VSS VSS gf180mcu_fd_sc_mcu7t5v0__dffsnq_1
XFILLER_55_136 VDD VDD VSS VSS gf180mcu_fd_sc_mcu7t5v0__fillcap_4
X_3027_ _3957_/Q _4045_/Q _3041_/S _3957_/D VDD VDD VSS VSS gf180mcu_fd_sc_mcu7t5v0__mux2_2
XFILLER_83_489 VDD VDD VSS VSS gf180mcu_fd_sc_mcu7t5v0__fill_1
XFILLER_71_629 VDD VDD VSS VSS gf180mcu_fd_sc_mcu7t5v0__fill_1
XFILLER_43_309 VDD VDD VSS VSS gf180mcu_fd_sc_mcu7t5v0__fill_1
XFILLER_52_821 VDD VDD VSS VSS gf180mcu_fd_sc_mcu7t5v0__fill_1
XFILLER_64_681 VDD VDD VSS VSS gf180mcu_fd_sc_mcu7t5v0__fill_1
XTAP_TAPCELL_ROW_104_1638 VDD VSS gf180mcu_fd_sc_mcu7t5v0__filltie
XFILLER_36_383 VDD VDD VSS VSS gf180mcu_fd_sc_mcu7t5v0__fill_2
X_3929_ _3929_/D _2279_/I _3981_/CLK _3929_/Q VDD VDD VSS VSS gf180mcu_fd_sc_mcu7t5v0__dffrnq_1
Xclkload4 clkload4/I clkload4/ZN VDD VDD VSS VSS gf180mcu_fd_sc_mcu7t5v0__inv_4
XFILLER_109_138 VDD VDD VSS VSS gf180mcu_fd_sc_mcu7t5v0__fill_2
XFILLER_50_37 VDD VDD VSS VSS gf180mcu_fd_sc_mcu7t5v0__fillcap_4
XFILLER_3_416 VDD VDD VSS VSS gf180mcu_fd_sc_mcu7t5v0__fillcap_4
XTAP_TAPCELL_ROW_115_1778 VDD VSS gf180mcu_fd_sc_mcu7t5v0__filltie
XFILLER_3_438 VDD VDD VSS VSS gf180mcu_fd_sc_mcu7t5v0__fillcap_8
XFILLER_120_303 VDD VDD VSS VSS gf180mcu_fd_sc_mcu7t5v0__fill_1
XFILLER_79_718 VDD VDD VSS VSS gf180mcu_fd_sc_mcu7t5v0__fillcap_4
XFILLER_78_217 VDD VDD VSS VSS gf180mcu_fd_sc_mcu7t5v0__fillcap_4
XFILLER_59_68 VDD VDD VSS VSS gf180mcu_fd_sc_mcu7t5v0__fill_2
XFILLER_120_369 VDD VDD VSS VSS gf180mcu_fd_sc_mcu7t5v0__fillcap_16
XFILLER_75_67 VDD VDD VSS VSS gf180mcu_fd_sc_mcu7t5v0__fill_2
XTAP_TAPCELL_ROW_17_507 VDD VSS gf180mcu_fd_sc_mcu7t5v0__filltie
XFILLER_34_309 VDD VDD VSS VSS gf180mcu_fd_sc_mcu7t5v0__fillcap_4
XFILLER_15_534 VDD VDD VSS VSS gf180mcu_fd_sc_mcu7t5v0__fillcap_16
XFILLER_61_139 VDD VDD VSS VSS gf180mcu_fd_sc_mcu7t5v0__fill_1
XFILLER_15_578 VDD VDD VSS VSS gf180mcu_fd_sc_mcu7t5v0__fillcap_32
XFILLER_70_662 VDD VDD VSS VSS gf180mcu_fd_sc_mcu7t5v0__fill_2
XFILLER_91_88 VDD VDD VSS VSS gf180mcu_fd_sc_mcu7t5v0__fillcap_8
XFILLER_42_375 VDD VDD VSS VSS gf180mcu_fd_sc_mcu7t5v0__fillcap_8
XFILLER_128_403 VDD VDD VSS VSS gf180mcu_fd_sc_mcu7t5v0__fillcap_8
XFILLER_7_766 VDD VDD VSS VSS gf180mcu_fd_sc_mcu7t5v0__fillcap_4
XFILLER_108_193 VDD VDD VSS VSS gf180mcu_fd_sc_mcu7t5v0__fill_2
XFILLER_112_804 VDD VDD VSS VSS gf180mcu_fd_sc_mcu7t5v0__fill_1
XFILLER_123_174 VDD VDD VSS VSS gf180mcu_fd_sc_mcu7t5v0__fillcap_16
X_2260_ _3925_/Q place72/Z place63/Z _3957_/Q _3965_/Q place67/Z _2261_/I VDD VDD
+ VSS VSS gf180mcu_fd_sc_mcu7t5v0__aoi222_1
XFILLER_97_559 VDD VDD VSS VSS gf180mcu_fd_sc_mcu7t5v0__fill_1
XFILLER_97_548 VDD VDD VSS VSS gf180mcu_fd_sc_mcu7t5v0__fill_2
XFILLER_84_209 VDD VDD VSS VSS gf180mcu_fd_sc_mcu7t5v0__fillcap_16
X_2191_ _3658_/Q _3666_/Q _3674_/Q _3682_/Q place79/Z place78/Z _2191_/Z VDD VDD VSS
+ VSS gf180mcu_fd_sc_mcu7t5v0__mux4_1
XFILLER_53_629 VDD VDD VSS VSS gf180mcu_fd_sc_mcu7t5v0__fill_1
XFILLER_34_887 VDD VDD VSS VSS gf180mcu_fd_sc_mcu7t5v0__fill_1
XTAP_TAPCELL_ROW_44_860 VDD VSS gf180mcu_fd_sc_mcu7t5v0__filltie
XFILLER_21_515 VDD VDD VSS VSS gf180mcu_fd_sc_mcu7t5v0__fill_2
X_1975_ _3935_/Q _4126_/Q _3936_/Q _4127_/Q _1977_/A1 VDD VDD VSS VSS gf180mcu_fd_sc_mcu7t5v0__aoi22_1
XFILLER_119_414 VDD VDD VSS VSS gf180mcu_fd_sc_mcu7t5v0__fillcap_4
X_3714_ _3714_/D _3733_/CLK _3714_/Q VDD VDD VSS VSS gf180mcu_fd_sc_mcu7t5v0__dffq_1
XTAP_TAPCELL_ROW_132_2012 VDD VSS gf180mcu_fd_sc_mcu7t5v0__filltie
XTAP_TAPCELL_ROW_132_2001 VDD VSS gf180mcu_fd_sc_mcu7t5v0__filltie
X_3645_ _3645_/D _3749_/CLK _3645_/Q VDD VDD VSS VSS gf180mcu_fd_sc_mcu7t5v0__dffq_1
X_3576_ _3873_/Q _3881_/Q _3769_/Q _3777_/Q place76/Z place75/Z _3576_/Z VDD VDD VSS
+ VSS gf180mcu_fd_sc_mcu7t5v0__mux4_1
XFILLER_114_163 VDD VDD VSS VSS gf180mcu_fd_sc_mcu7t5v0__fillcap_8
XFILLER_130_623 VDD VDD VSS VSS gf180mcu_fd_sc_mcu7t5v0__fill_1
X_2458_ place81/Z _3704_/Q _2466_/S _3704_/D VDD VDD VSS VSS gf180mcu_fd_sc_mcu7t5v0__mux2_2
XFILLER_130_667 VDD VDD VSS VSS gf180mcu_fd_sc_mcu7t5v0__fillcap_16
XPHY_EDGE_ROW_89_Right_89 VDD VSS gf180mcu_fd_sc_mcu7t5v0__endcap
XFILLER_84_732 VDD VDD VSS VSS gf180mcu_fd_sc_mcu7t5v0__fill_2
X_2389_ _3673_/Q _4071_/Q _2395_/S _3673_/D VDD VDD VSS VSS gf180mcu_fd_sc_mcu7t5v0__mux2_2
XFILLER_69_795 VDD VDD VSS VSS gf180mcu_fd_sc_mcu7t5v0__fill_2
X_4128_ _4128_/D _2279_/I _4128_/CLK _4128_/Q VDD VDD VSS VSS gf180mcu_fd_sc_mcu7t5v0__dffrnq_1
XFILLER_29_648 VDD VDD VSS VSS gf180mcu_fd_sc_mcu7t5v0__fill_1
X_4059_ _4059_/D input92/Z _4130_/CLK _4059_/Q VDD VDD VSS VSS gf180mcu_fd_sc_mcu7t5v0__dffrnq_1
XFILLER_84_787 VDD VDD VSS VSS gf180mcu_fd_sc_mcu7t5v0__fillcap_16
XFILLER_84_776 VDD VDD VSS VSS gf180mcu_fd_sc_mcu7t5v0__fillcap_4
XFILLER_83_286 VDD VDD VSS VSS gf180mcu_fd_sc_mcu7t5v0__fill_2
XFILLER_45_59 VDD VDD VSS VSS gf180mcu_fd_sc_mcu7t5v0__fillcap_8
XFILLER_101_10 VDD VDD VSS VSS gf180mcu_fd_sc_mcu7t5v0__fill_2
XTAP_TAPCELL_ROW_65_1132 VDD VSS gf180mcu_fd_sc_mcu7t5v0__filltie
XPHY_EDGE_ROW_98_Right_98 VDD VSS gf180mcu_fd_sc_mcu7t5v0__endcap
XFILLER_12_515 VDD VDD VSS VSS gf180mcu_fd_sc_mcu7t5v0__fillcap_8
XFILLER_51_150 VDD VDD VSS VSS gf180mcu_fd_sc_mcu7t5v0__fillcap_4
XFILLER_52_695 VDD VDD VSS VSS gf180mcu_fd_sc_mcu7t5v0__fill_1
XFILLER_12_559 VDD VDD VSS VSS gf180mcu_fd_sc_mcu7t5v0__fillcap_4
XTAP_TAPCELL_ROW_22_576 VDD VSS gf180mcu_fd_sc_mcu7t5v0__filltie
XTAP_TAPCELL_ROW_117_1807 VDD VSS gf180mcu_fd_sc_mcu7t5v0__filltie
XFILLER_125_417 VDD VDD VSS VSS gf180mcu_fd_sc_mcu7t5v0__fill_2
XTAP_TAPCELL_ROW_76_1272 VDD VSS gf180mcu_fd_sc_mcu7t5v0__filltie
XFILLER_121_612 VDD VDD VSS VSS gf180mcu_fd_sc_mcu7t5v0__fillcap_16
XFILLER_0_920 VDD VDD VSS VSS gf180mcu_fd_sc_mcu7t5v0__fillcap_8
XFILLER_121_678 VDD VDD VSS VSS gf180mcu_fd_sc_mcu7t5v0__fillcap_16
XFILLER_120_177 VDD VDD VSS VSS gf180mcu_fd_sc_mcu7t5v0__fillcap_32
XTAP_TAPCELL_ROW_128_1947 VDD VSS gf180mcu_fd_sc_mcu7t5v0__filltie
XFILLER_75_787 VDD VDD VSS VSS gf180mcu_fd_sc_mcu7t5v0__fill_2
XFILLER_35_629 VDD VDD VSS VSS gf180mcu_fd_sc_mcu7t5v0__fill_1
XFILLER_34_139 VDD VDD VSS VSS gf180mcu_fd_sc_mcu7t5v0__fillcap_4
XFILLER_15_342 VDD VDD VSS VSS gf180mcu_fd_sc_mcu7t5v0__fillcap_8
XFILLER_43_640 VDD VDD VSS VSS gf180mcu_fd_sc_mcu7t5v0__fill_1
X_3430_ place91/Z _4100_/Q _3430_/Z VDD VDD VSS VSS gf180mcu_fd_sc_mcu7t5v0__xor2_1
X_3361_ _3370_/A1 _3361_/A2 _4082_/Q _3362_/B VDD VDD VSS VSS gf180mcu_fd_sc_mcu7t5v0__oai21_1
XFILLER_112_612 VDD VDD VSS VSS gf180mcu_fd_sc_mcu7t5v0__fillcap_32
XFILLER_112_667 VDD VDD VSS VSS gf180mcu_fd_sc_mcu7t5v0__fillcap_32
XFILLER_100_807 VDD VDD VSS VSS gf180mcu_fd_sc_mcu7t5v0__fillcap_4
X_3292_ _4167_/Q _3292_/A2 _3293_/A2 VDD VDD VSS VSS gf180mcu_fd_sc_mcu7t5v0__xnor2_1
X_2243_ _2243_/I _2243_/ZN VDD VDD VSS VSS gf180mcu_fd_sc_mcu7t5v0__inv_1
XFILLER_25_2 VDD VDD VSS VSS gf180mcu_fd_sc_mcu7t5v0__fillcap_16
X_2174_ _3657_/Q _3665_/Q _3673_/Q _3681_/Q place79/Z place78/Z _2174_/Z VDD VDD VSS
+ VSS gf180mcu_fd_sc_mcu7t5v0__mux4_1
XFILLER_65_220 VDD VDD VSS VSS gf180mcu_fd_sc_mcu7t5v0__fill_2
XFILLER_93_562 VDD VDD VSS VSS gf180mcu_fd_sc_mcu7t5v0__fillcap_32
XFILLER_81_702 VDD VDD VSS VSS gf180mcu_fd_sc_mcu7t5v0__fillcap_8
XFILLER_19_681 VDD VDD VSS VSS gf180mcu_fd_sc_mcu7t5v0__fill_2
XFILLER_22_835 VDD VDD VSS VSS gf180mcu_fd_sc_mcu7t5v0__fillcap_32
XFILLER_61_492 VDD VDD VSS VSS gf180mcu_fd_sc_mcu7t5v0__fillcap_64
XFILLER_21_367 VDD VDD VSS VSS gf180mcu_fd_sc_mcu7t5v0__fillcap_4
XFILLER_31_28 VDD VDD VSS VSS gf180mcu_fd_sc_mcu7t5v0__fill_1
XTAP_TAPCELL_ROW_60_1062 VDD VSS gf180mcu_fd_sc_mcu7t5v0__filltie
X_1889_ _2887_/A1 _4138_/Q _1935_/A4 _1889_/B _1899_/A2 VDD VDD VSS VSS gf180mcu_fd_sc_mcu7t5v0__oai31_1
XFILLER_131_932 VDD VDD VSS VSS gf180mcu_fd_sc_mcu7t5v0__fill_2
XTAP_TAPCELL_ROW_112_1748 VDD VSS gf180mcu_fd_sc_mcu7t5v0__filltie
XTAP_TAPCELL_ROW_112_1737 VDD VSS gf180mcu_fd_sc_mcu7t5v0__filltie
XFILLER_102_100 VDD VDD VSS VSS gf180mcu_fd_sc_mcu7t5v0__fillcap_4
Xinput117 hold212/Z _3131_/I1 VDD VDD VSS VSS gf180mcu_fd_sc_mcu7t5v0__dlyb_1
XFILLER_89_868 VDD VDD VSS VSS gf180mcu_fd_sc_mcu7t5v0__fill_1
Xinput106 hold199/Z _1965_/A1 VDD VDD VSS VSS gf180mcu_fd_sc_mcu7t5v0__dlyb_1
Xinput128 hold218/Z _3152_/I1 VDD VDD VSS VSS gf180mcu_fd_sc_mcu7t5v0__dlyb_1
XFILLER_102_177 VDD VDD VSS VSS gf180mcu_fd_sc_mcu7t5v0__fillcap_32
Xinput139 hold220/Z _3112_/I1 VDD VDD VSS VSS gf180mcu_fd_sc_mcu7t5v0__dlyb_1
XTAP_TAPCELL_ROW_27_635 VDD VSS gf180mcu_fd_sc_mcu7t5v0__filltie
XFILLER_71_212 VDD VDD VSS VSS gf180mcu_fd_sc_mcu7t5v0__fillcap_4
XTAP_TAPCELL_ROW_123_1888 VDD VSS gf180mcu_fd_sc_mcu7t5v0__filltie
XTAP_TAPCELL_ROW_55_999 VDD VSS gf180mcu_fd_sc_mcu7t5v0__filltie
XFILLER_71_278 VDD VDD VSS VSS gf180mcu_fd_sc_mcu7t5v0__fill_2
XFILLER_12_345 VDD VDD VSS VSS gf180mcu_fd_sc_mcu7t5v0__fill_2
XPHY_EDGE_ROW_117_Right_117 VDD VSS gf180mcu_fd_sc_mcu7t5v0__endcap
XFILLER_13_879 VDD VDD VSS VSS gf180mcu_fd_sc_mcu7t5v0__fill_2
XTAP_TAPCELL_ROW_78_1301 VDD VSS gf180mcu_fd_sc_mcu7t5v0__filltie
XFILLER_12_389 VDD VDD VSS VSS gf180mcu_fd_sc_mcu7t5v0__fill_1
XFILLER_126_737 VDD VDD VSS VSS gf180mcu_fd_sc_mcu7t5v0__fillcap_32
XFILLER_125_203 VDD VDD VSS VSS gf180mcu_fd_sc_mcu7t5v0__fillcap_4
XFILLER_106_483 VDD VDD VSS VSS gf180mcu_fd_sc_mcu7t5v0__fill_1
XFILLER_97_65 VDD VDD VSS VSS gf180mcu_fd_sc_mcu7t5v0__fillcap_4
XFILLER_4_599 VDD VDD VSS VSS gf180mcu_fd_sc_mcu7t5v0__fill_1
XFILLER_0_750 VDD VDD VSS VSS gf180mcu_fd_sc_mcu7t5v0__fillcap_32
XFILLER_95_838 VDD VDD VSS VSS gf180mcu_fd_sc_mcu7t5v0__fill_2
XTAP_TAPCELL_ROW_7_382 VDD VSS gf180mcu_fd_sc_mcu7t5v0__filltie
XTAP_TAPCELL_ROW_7_371 VDD VSS gf180mcu_fd_sc_mcu7t5v0__filltie
XTAP_TAPCELL_ROW_89_1441 VDD VSS gf180mcu_fd_sc_mcu7t5v0__filltie
XFILLER_75_562 VDD VDD VSS VSS gf180mcu_fd_sc_mcu7t5v0__fill_2
XFILLER_50_407 VDD VDD VSS VSS gf180mcu_fd_sc_mcu7t5v0__fill_1
XFILLER_50_429 VDD VDD VSS VSS gf180mcu_fd_sc_mcu7t5v0__fillcap_16
XFILLER_31_632 VDD VDD VSS VSS gf180mcu_fd_sc_mcu7t5v0__fillcap_16
XFILLER_43_492 VDD VDD VSS VSS gf180mcu_fd_sc_mcu7t5v0__fillcap_32
XFILLER_87_4 VDD VDD VSS VSS gf180mcu_fd_sc_mcu7t5v0__fill_1
X_2861_ place86/Z _3881_/Q _2867_/S _3881_/D VDD VDD VSS VSS gf180mcu_fd_sc_mcu7t5v0__mux2_2
X_1812_ _2905_/A1 _1934_/I1 _1812_/Z VDD VDD VSS VSS gf180mcu_fd_sc_mcu7t5v0__xor2_1
XFILLER_7_63 VDD VDD VSS VSS gf180mcu_fd_sc_mcu7t5v0__fillcap_4
XFILLER_132_718 VDD VDD VSS VSS gf180mcu_fd_sc_mcu7t5v0__fill_1
XFILLER_132_707 VDD VDD VSS VSS gf180mcu_fd_sc_mcu7t5v0__fillcap_4
XFILLER_131_206 VDD VDD VSS VSS gf180mcu_fd_sc_mcu7t5v0__fillcap_4
XFILLER_116_247 VDD VDD VSS VSS gf180mcu_fd_sc_mcu7t5v0__fillcap_64
X_3413_ _3413_/A1 _3413_/A2 _3413_/Z VDD VDD VSS VSS gf180mcu_fd_sc_mcu7t5v0__or2_1
XFILLER_113_932 VDD VDD VSS VSS gf180mcu_fd_sc_mcu7t5v0__fill_2
XFILLER_97_142 VDD VDD VSS VSS gf180mcu_fd_sc_mcu7t5v0__fillcap_16
X_3344_ _3347_/B _3344_/A2 _3344_/B _3345_/A2 VDD VDD VSS VSS gf180mcu_fd_sc_mcu7t5v0__oai21_1
XFILLER_97_175 VDD VDD VSS VSS gf180mcu_fd_sc_mcu7t5v0__fillcap_32
X_3275_ _4064_/Q _3256_/Z _3276_/B VDD VDD VSS VSS gf180mcu_fd_sc_mcu7t5v0__nand2_1
XFILLER_58_518 VDD VDD VSS VSS gf180mcu_fd_sc_mcu7t5v0__fill_1
X_2226_ _3894_/Q place68/Z place63/Z _3942_/Q place67/Z _4086_/Q _2227_/A2 VDD VDD
+ VSS VSS gf180mcu_fd_sc_mcu7t5v0__aoi222_1
XFILLER_94_871 VDD VDD VSS VSS gf180mcu_fd_sc_mcu7t5v0__fillcap_4
XFILLER_38_242 VDD VDD VSS VSS gf180mcu_fd_sc_mcu7t5v0__fill_2
XFILLER_39_765 VDD VDD VSS VSS gf180mcu_fd_sc_mcu7t5v0__fillcap_4
XFILLER_66_551 VDD VDD VSS VSS gf180mcu_fd_sc_mcu7t5v0__fillcap_4
XFILLER_94_893 VDD VDD VSS VSS gf180mcu_fd_sc_mcu7t5v0__fillcap_8
XFILLER_38_297 VDD VDD VSS VSS gf180mcu_fd_sc_mcu7t5v0__fillcap_16
X_2157_ _3632_/Q _3688_/Q _3696_/Q _3704_/Q place79/Z place78/Z _2157_/Z VDD VDD VSS
+ VSS gf180mcu_fd_sc_mcu7t5v0__mux4_1
X_2088_ _2008_/Z _2088_/A2 _2088_/B _4145_/D VDD VDD VSS VSS gf180mcu_fd_sc_mcu7t5v0__oai21_4
XFILLER_41_418 VDD VDD VSS VSS gf180mcu_fd_sc_mcu7t5v0__fill_2
XTAP_TAPCELL_ROW_52_958 VDD VSS gf180mcu_fd_sc_mcu7t5v0__filltie
XFILLER_108_737 VDD VDD VSS VSS gf180mcu_fd_sc_mcu7t5v0__fillcap_16
XFILLER_123_718 VDD VDD VSS VSS gf180mcu_fd_sc_mcu7t5v0__fillcap_8
XFILLER_107_269 VDD VDD VSS VSS gf180mcu_fd_sc_mcu7t5v0__fill_2
XFILLER_89_632 VDD VDD VSS VSS gf180mcu_fd_sc_mcu7t5v0__fillcap_32
XTAP_TAPCELL_ROW_73_1231 VDD VSS gf180mcu_fd_sc_mcu7t5v0__filltie
XFILLER_131_751 VDD VDD VSS VSS gf180mcu_fd_sc_mcu7t5v0__fill_2
XFILLER_1_536 VDD VDD VSS VSS gf180mcu_fd_sc_mcu7t5v0__fillcap_16
XFILLER_103_486 VDD VDD VSS VSS gf180mcu_fd_sc_mcu7t5v0__fillcap_4
XTAP_TAPCELL_ROW_4_341 VDD VSS gf180mcu_fd_sc_mcu7t5v0__filltie
XTAP_TAPCELL_ROW_125_1906 VDD VSS gf180mcu_fd_sc_mcu7t5v0__filltie
XFILLER_57_562 VDD VDD VSS VSS gf180mcu_fd_sc_mcu7t5v0__fillcap_64
XTAP_TAPCELL_ROW_125_1917 VDD VSS gf180mcu_fd_sc_mcu7t5v0__filltie
XFILLER_83_34 VDD VDD VSS VSS gf180mcu_fd_sc_mcu7t5v0__fillcap_32
XFILLER_72_521 VDD VDD VSS VSS gf180mcu_fd_sc_mcu7t5v0__fillcap_4
XFILLER_44_201 VDD VDD VSS VSS gf180mcu_fd_sc_mcu7t5v0__fillcap_4
XFILLER_60_705 VDD VDD VSS VSS gf180mcu_fd_sc_mcu7t5v0__fill_1
XTAP_TAPCELL_ROW_84_1382 VDD VSS gf180mcu_fd_sc_mcu7t5v0__filltie
XFILLER_13_632 VDD VDD VSS VSS gf180mcu_fd_sc_mcu7t5v0__fillcap_32
XFILLER_25_492 VDD VDD VSS VSS gf180mcu_fd_sc_mcu7t5v0__fillcap_64
XFILLER_40_451 VDD VDD VSS VSS gf180mcu_fd_sc_mcu7t5v0__fillcap_4
XFILLER_13_698 VDD VDD VSS VSS gf180mcu_fd_sc_mcu7t5v0__fill_2
XFILLER_5_842 VDD VDD VSS VSS gf180mcu_fd_sc_mcu7t5v0__fillcap_64
XFILLER_99_418 VDD VDD VSS VSS gf180mcu_fd_sc_mcu7t5v0__fill_2
XFILLER_4_352 VDD VDD VSS VSS gf180mcu_fd_sc_mcu7t5v0__fill_1
XFILLER_113_206 VDD VDD VSS VSS gf180mcu_fd_sc_mcu7t5v0__fillcap_4
XFILLER_113_239 VDD VDD VSS VSS gf180mcu_fd_sc_mcu7t5v0__fill_2
XFILLER_79_142 VDD VDD VSS VSS gf180mcu_fd_sc_mcu7t5v0__fillcap_8
X_3060_ _4052_/Q _3972_/Q _3081_/S _3972_/D VDD VDD VSS VSS gf180mcu_fd_sc_mcu7t5v0__mux2_2
XFILLER_0_580 VDD VDD VSS VSS gf180mcu_fd_sc_mcu7t5v0__fillcap_32
XFILLER_67_348 VDD VDD VSS VSS gf180mcu_fd_sc_mcu7t5v0__fill_2
XFILLER_76_893 VDD VDD VSS VSS gf180mcu_fd_sc_mcu7t5v0__fill_1
XFILLER_35_212 VDD VDD VSS VSS gf180mcu_fd_sc_mcu7t5v0__fillcap_16
XFILLER_36_757 VDD VDD VSS VSS gf180mcu_fd_sc_mcu7t5v0__fill_2
XFILLER_63_554 VDD VDD VSS VSS gf180mcu_fd_sc_mcu7t5v0__fillcap_4
XFILLER_90_384 VDD VDD VSS VSS gf180mcu_fd_sc_mcu7t5v0__fill_1
X_3962_ _3962_/D _2279_/I _4128_/CLK _3962_/Q VDD VDD VSS VSS gf180mcu_fd_sc_mcu7t5v0__dffrnq_1
X_3893_ _3893_/D _4157_/RN _3946_/CLK _3893_/Q VDD VDD VSS VSS gf180mcu_fd_sc_mcu7t5v0__dffrnq_1
X_2844_ place86/Z _3873_/Q _2850_/S _3873_/D VDD VDD VSS VSS gf180mcu_fd_sc_mcu7t5v0__mux2_2
XFILLER_112_261 VDD VDD VSS VSS gf180mcu_fd_sc_mcu7t5v0__fill_1
XFILLER_98_451 VDD VDD VSS VSS gf180mcu_fd_sc_mcu7t5v0__fillcap_4
XFILLER_86_613 VDD VDD VSS VSS gf180mcu_fd_sc_mcu7t5v0__fill_1
X_3327_ _4076_/Q _3332_/A1 VDD VDD VSS VSS gf180mcu_fd_sc_mcu7t5v0__clkinv_1
XFILLER_59_838 VDD VDD VSS VSS gf180mcu_fd_sc_mcu7t5v0__fill_2
XTAP_TAPCELL_ROW_1_300 VDD VSS gf180mcu_fd_sc_mcu7t5v0__filltie
XFILLER_27_702 VDD VDD VSS VSS gf180mcu_fd_sc_mcu7t5v0__fillcap_4
X_3258_ _4079_/Q _3342_/B _3607_/A3 VDD VDD VSS VSS gf180mcu_fd_sc_mcu7t5v0__nand2_1
XFILLER_39_540 VDD VDD VSS VSS gf180mcu_fd_sc_mcu7t5v0__fillcap_8
XFILLER_39_562 VDD VDD VSS VSS gf180mcu_fd_sc_mcu7t5v0__fill_2
XFILLER_100_489 VDD VDD VSS VSS gf180mcu_fd_sc_mcu7t5v0__fillcap_8
X_2209_ _3636_/Q _3692_/Q _3700_/Q _3708_/Q place79/Z place78/Z _2209_/Z VDD VDD VSS
+ VSS gf180mcu_fd_sc_mcu7t5v0__mux4_1
XFILLER_66_381 VDD VDD VSS VSS gf180mcu_fd_sc_mcu7t5v0__fillcap_4
XFILLER_82_885 VDD VDD VSS VSS gf180mcu_fd_sc_mcu7t5v0__fillcap_4
XTAP_TAPCELL_ROW_37_763 VDD VSS gf180mcu_fd_sc_mcu7t5v0__filltie
XFILLER_42_716 VDD VDD VSS VSS gf180mcu_fd_sc_mcu7t5v0__fillcap_16
XTAP_TAPCELL_ROW_120_1847 VDD VSS gf180mcu_fd_sc_mcu7t5v0__filltie
XTAP_TAPCELL_ROW_9_400 VDD VSS gf180mcu_fd_sc_mcu7t5v0__filltie
XFILLER_78_56 VDD VDD VSS VSS gf180mcu_fd_sc_mcu7t5v0__fill_1
XTAP_TAPCELL_ROW_131_1987 VDD VSS gf180mcu_fd_sc_mcu7t5v0__filltie
XFILLER_110_209 VDD VDD VSS VSS gf180mcu_fd_sc_mcu7t5v0__fillcap_4
XFILLER_1_377 VDD VDD VSS VSS gf180mcu_fd_sc_mcu7t5v0__fillcap_32
XFILLER_103_272 VDD VDD VSS VSS gf180mcu_fd_sc_mcu7t5v0__fillcap_8
XFILLER_49_326 VDD VDD VSS VSS gf180mcu_fd_sc_mcu7t5v0__fillcap_16
XFILLER_92_605 VDD VDD VSS VSS gf180mcu_fd_sc_mcu7t5v0__fillcap_4
XTAP_TAPCELL_ROW_86_1400 VDD VSS gf180mcu_fd_sc_mcu7t5v0__filltie
XFILLER_17_212 VDD VDD VSS VSS gf180mcu_fd_sc_mcu7t5v0__fillcap_64
XFILLER_64_329 VDD VDD VSS VSS gf180mcu_fd_sc_mcu7t5v0__fill_2
XFILLER_18_768 VDD VDD VSS VSS gf180mcu_fd_sc_mcu7t5v0__fillcap_32
XFILLER_60_502 VDD VDD VSS VSS gf180mcu_fd_sc_mcu7t5v0__fillcap_16
XFILLER_60_524 VDD VDD VSS VSS gf180mcu_fd_sc_mcu7t5v0__fill_1
XFILLER_72_384 VDD VDD VSS VSS gf180mcu_fd_sc_mcu7t5v0__fill_1
XTAP_TAPCELL_ROW_15_479 VDD VSS gf180mcu_fd_sc_mcu7t5v0__filltie
XFILLER_9_422 VDD VDD VSS VSS gf180mcu_fd_sc_mcu7t5v0__fillcap_64
XTAP_TAPCELL_ROW_97_1551 VDD VSS gf180mcu_fd_sc_mcu7t5v0__filltie
X_2560_ _3749_/Q place82/Z _2574_/S _3749_/D VDD VDD VSS VSS gf180mcu_fd_sc_mcu7t5v0__mux2_2
X_2491_ _3718_/Q _4068_/Q _2503_/S _3718_/D VDD VDD VSS VSS gf180mcu_fd_sc_mcu7t5v0__mux2_2
X_4161_ _4161_/D input92/Z _4166_/CLK _4161_/Q VDD VDD VSS VSS gf180mcu_fd_sc_mcu7t5v0__dffrnq_1
XFILLER_96_933 VDD VDD VSS VSS gf180mcu_fd_sc_mcu7t5v0__fill_1
XFILLER_67_123 VDD VDD VSS VSS gf180mcu_fd_sc_mcu7t5v0__fillcap_16
XFILLER_68_635 VDD VDD VSS VSS gf180mcu_fd_sc_mcu7t5v0__fill_1
X_4092_ _4092_/D _2279_/I _4092_/CLK _4092_/Q VDD VDD VSS VSS gf180mcu_fd_sc_mcu7t5v0__dffrnq_2
X_3112_ _3997_/Q _3112_/I1 _3160_/S _3997_/D VDD VDD VSS VSS gf180mcu_fd_sc_mcu7t5v0__mux2_2
XFILLER_68_679 VDD VDD VSS VSS gf180mcu_fd_sc_mcu7t5v0__fill_2
XFILLER_83_649 VDD VDD VSS VSS gf180mcu_fd_sc_mcu7t5v0__fill_1
XFILLER_82_104 VDD VDD VSS VSS gf180mcu_fd_sc_mcu7t5v0__fill_1
XFILLER_82_115 VDD VDD VSS VSS gf180mcu_fd_sc_mcu7t5v0__fill_1
X_3043_ _4056_/Q _3043_/A2 _3043_/Z VDD VDD VSS VSS gf180mcu_fd_sc_mcu7t5v0__or2_1
XFILLER_36_521 VDD VDD VSS VSS gf180mcu_fd_sc_mcu7t5v0__fillcap_4
XFILLER_55_318 VDD VDD VSS VSS gf180mcu_fd_sc_mcu7t5v0__fill_1
XFILLER_48_381 VDD VDD VSS VSS gf180mcu_fd_sc_mcu7t5v0__fillcap_4
XFILLER_90_170 VDD VDD VSS VSS gf180mcu_fd_sc_mcu7t5v0__fillcap_4
XTAP_TAPCELL_ROW_34_722 VDD VSS gf180mcu_fd_sc_mcu7t5v0__filltie
XTAP_TAPCELL_ROW_34_733 VDD VSS gf180mcu_fd_sc_mcu7t5v0__filltie
XFILLER_51_546 VDD VDD VSS VSS gf180mcu_fd_sc_mcu7t5v0__fillcap_8
X_3945_ _3945_/D _4157_/RN _3976_/CLK _3945_/Q VDD VDD VSS VSS gf180mcu_fd_sc_mcu7t5v0__dffrnq_1
XFILLER_20_933 VDD VDD VSS VSS gf180mcu_fd_sc_mcu7t5v0__fill_1
X_3876_ _3876_/D _3877_/CLK _3876_/Q VDD VDD VSS VSS gf180mcu_fd_sc_mcu7t5v0__dffq_1
XFILLER_118_821 VDD VDD VSS VSS gf180mcu_fd_sc_mcu7t5v0__fillcap_16
X_2827_ place86/Z _3865_/Q _2833_/S _3865_/D VDD VDD VSS VSS gf180mcu_fd_sc_mcu7t5v0__mux2_2
X_2758_ _3833_/Q place86/Z _2764_/S _3833_/D VDD VDD VSS VSS gf180mcu_fd_sc_mcu7t5v0__mux2_2
XTAP_TAPCELL_ROW_57_1023 VDD VSS gf180mcu_fd_sc_mcu7t5v0__filltie
XFILLER_105_559 VDD VDD VSS VSS gf180mcu_fd_sc_mcu7t5v0__fill_1
X_2689_ place85/Z _3802_/Q _2693_/S _3802_/D VDD VDD VSS VSS gf180mcu_fd_sc_mcu7t5v0__mux2_2
XFILLER_120_507 VDD VDD VSS VSS gf180mcu_fd_sc_mcu7t5v0__fillcap_16
XFILLER_87_900 VDD VDD VSS VSS gf180mcu_fd_sc_mcu7t5v0__fillcap_8
XTAP_TAPCELL_ROW_70_1201 VDD VSS gf180mcu_fd_sc_mcu7t5v0__filltie
XFILLER_113_570 VDD VDD VSS VSS gf180mcu_fd_sc_mcu7t5v0__fill_2
XFILLER_48_37 VDD VDD VSS VSS gf180mcu_fd_sc_mcu7t5v0__fillcap_64
XTAP_TAPCELL_ROW_109_1709 VDD VSS gf180mcu_fd_sc_mcu7t5v0__filltie
XFILLER_86_454 VDD VDD VSS VSS gf180mcu_fd_sc_mcu7t5v0__fill_1
XFILLER_73_137 VDD VDD VSS VSS gf180mcu_fd_sc_mcu7t5v0__fill_2
XFILLER_27_543 VDD VDD VSS VSS gf180mcu_fd_sc_mcu7t5v0__fillcap_16
XTAP_TAPCELL_ROW_68_1174 VDD VSS gf180mcu_fd_sc_mcu7t5v0__filltie
XFILLER_54_384 VDD VDD VSS VSS gf180mcu_fd_sc_mcu7t5v0__fill_1
XFILLER_70_844 VDD VDD VSS VSS gf180mcu_fd_sc_mcu7t5v0__fill_2
XTAP_TAPCELL_ROW_81_1341 VDD VSS gf180mcu_fd_sc_mcu7t5v0__filltie
XFILLER_30_708 VDD VDD VSS VSS gf180mcu_fd_sc_mcu7t5v0__fillcap_16
XFILLER_42_568 VDD VDD VSS VSS gf180mcu_fd_sc_mcu7t5v0__fill_1
XFILLER_70_877 VDD VDD VSS VSS gf180mcu_fd_sc_mcu7t5v0__fillcap_4
XFILLER_10_410 VDD VDD VSS VSS gf180mcu_fd_sc_mcu7t5v0__fillcap_32
XTAP_TAPCELL_ROW_12_438 VDD VSS gf180mcu_fd_sc_mcu7t5v0__filltie
XFILLER_50_590 VDD VDD VSS VSS gf180mcu_fd_sc_mcu7t5v0__fill_1
XFILLER_10_454 VDD VDD VSS VSS gf180mcu_fd_sc_mcu7t5v0__fill_1
XFILLER_129_84 VDD VDD VSS VSS gf180mcu_fd_sc_mcu7t5v0__fillcap_32
XFILLER_124_802 VDD VDD VSS VSS gf180mcu_fd_sc_mcu7t5v0__fill_2
XFILLER_108_342 VDD VDD VSS VSS gf180mcu_fd_sc_mcu7t5v0__fillcap_32
XFILLER_108_331 VDD VDD VSS VSS gf180mcu_fd_sc_mcu7t5v0__fill_1
XFILLER_6_447 VDD VDD VSS VSS gf180mcu_fd_sc_mcu7t5v0__fillcap_8
XFILLER_89_88 VDD VDD VSS VSS gf180mcu_fd_sc_mcu7t5v0__fill_2
XTAP_TAPCELL_ROW_92_1481 VDD VSS gf180mcu_fd_sc_mcu7t5v0__filltie
XFILLER_2_664 VDD VDD VSS VSS gf180mcu_fd_sc_mcu7t5v0__fill_1
XFILLER_132_890 VDD VDD VSS VSS gf180mcu_fd_sc_mcu7t5v0__fill_2
XPHY_EDGE_ROW_8_Left_141 VDD VSS gf180mcu_fd_sc_mcu7t5v0__endcap
XFILLER_1_174 VDD VDD VSS VSS gf180mcu_fd_sc_mcu7t5v0__fillcap_4
XFILLER_77_454 VDD VDD VSS VSS gf180mcu_fd_sc_mcu7t5v0__fillcap_16
XFILLER_92_413 VDD VDD VSS VSS gf180mcu_fd_sc_mcu7t5v0__fillcap_16
XFILLER_18_521 VDD VDD VSS VSS gf180mcu_fd_sc_mcu7t5v0__fillcap_4
XFILLER_18_565 VDD VDD VSS VSS gf180mcu_fd_sc_mcu7t5v0__fill_1
XFILLER_60_365 VDD VDD VSS VSS gf180mcu_fd_sc_mcu7t5v0__fillcap_4
X_1991_ _3968_/Q _3967_/Q _3966_/Q _3965_/Q _1992_/A2 VDD VDD VSS VSS gf180mcu_fd_sc_mcu7t5v0__nor4_1
X_3730_ _3730_/D _3738_/CLK _3730_/Q VDD VDD VSS VSS gf180mcu_fd_sc_mcu7t5v0__dffq_1
XFILLER_119_629 VDD VDD VSS VSS gf180mcu_fd_sc_mcu7t5v0__fill_1
X_3661_ _3661_/D _3749_/CLK _3661_/Q VDD VDD VSS VSS gf180mcu_fd_sc_mcu7t5v0__dffq_1
XFILLER_127_640 VDD VDD VSS VSS gf180mcu_fd_sc_mcu7t5v0__fillcap_4
Xclkload44 _4126_/CLK clkload44/ZN VDD VDD VSS VSS gf180mcu_fd_sc_mcu7t5v0__clkinv_4
Xclkload22 _4028_/CLK clkload22/Z VDD VDD VSS VSS gf180mcu_fd_sc_mcu7t5v0__clkbuf_2
Xclkload33 _4167_/CLK clkload33/Z VDD VDD VSS VSS gf180mcu_fd_sc_mcu7t5v0__clkbuf_2
X_3592_ _3588_/Z _3589_/Z _3590_/Z _3591_/Z place74/Z _4119_/Q _3592_/Z VDD VDD VSS
+ VSS gf180mcu_fd_sc_mcu7t5v0__mux4_1
Xclkload11 _3877_/CLK clkload11/ZN VDD VDD VSS VSS gf180mcu_fd_sc_mcu7t5v0__clkinv_1
Xclkload55 _3749_/CLK clkload55/Z VDD VDD VSS VSS gf180mcu_fd_sc_mcu7t5v0__clkbuf_2
XFILLER_55_2 VDD VDD VSS VSS gf180mcu_fd_sc_mcu7t5v0__fillcap_8
XFILLER_126_194 VDD VDD VSS VSS gf180mcu_fd_sc_mcu7t5v0__fillcap_8
XFILLER_115_846 VDD VDD VSS VSS gf180mcu_fd_sc_mcu7t5v0__fill_2
XFILLER_87_207 VDD VDD VSS VSS gf180mcu_fd_sc_mcu7t5v0__fill_2
XFILLER_96_730 VDD VDD VSS VSS gf180mcu_fd_sc_mcu7t5v0__fillcap_4
X_4144_ _4144_/D _4148_/RN _4147_/CLK _4144_/Q VDD VDD VSS VSS gf180mcu_fd_sc_mcu7t5v0__dffrnq_1
XFILLER_68_454 VDD VDD VSS VSS gf180mcu_fd_sc_mcu7t5v0__fill_1
XFILLER_68_465 VDD VDD VSS VSS gf180mcu_fd_sc_mcu7t5v0__fill_1
XFILLER_18_18 VDD VDD VSS VSS gf180mcu_fd_sc_mcu7t5v0__fill_2
X_4075_ _4075_/D input92/Z _4076_/CLK _4075_/Q VDD VDD VSS VSS gf180mcu_fd_sc_mcu7t5v0__dffsnq_1
XFILLER_52_800 VDD VDD VSS VSS gf180mcu_fd_sc_mcu7t5v0__fillcap_4
XFILLER_70_107 VDD VDD VSS VSS gf180mcu_fd_sc_mcu7t5v0__fillcap_64
XTAP_TAPCELL_ROW_104_1639 VDD VSS gf180mcu_fd_sc_mcu7t5v0__filltie
XTAP_TAPCELL_ROW_47_891 VDD VSS gf180mcu_fd_sc_mcu7t5v0__filltie
XFILLER_52_877 VDD VDD VSS VSS gf180mcu_fd_sc_mcu7t5v0__fillcap_8
X_3928_ _3928_/D _2279_/I _3968_/CLK _3928_/Q VDD VDD VSS VSS gf180mcu_fd_sc_mcu7t5v0__dffrnq_1
Xclkload5 clkload5/I clkload5/ZN VDD VDD VSS VSS gf180mcu_fd_sc_mcu7t5v0__inv_4
X_3859_ _3859_/D clkload7/I _3859_/Q VDD VDD VSS VSS gf180mcu_fd_sc_mcu7t5v0__dffq_1
XFILLER_118_662 VDD VDD VSS VSS gf180mcu_fd_sc_mcu7t5v0__fill_2
XTAP_TAPCELL_ROW_115_1779 VDD VSS gf180mcu_fd_sc_mcu7t5v0__filltie
XFILLER_120_337 VDD VDD VSS VSS gf180mcu_fd_sc_mcu7t5v0__fill_2
XFILLER_78_229 VDD VDD VSS VSS gf180mcu_fd_sc_mcu7t5v0__fill_1
XFILLER_101_562 VDD VDD VSS VSS gf180mcu_fd_sc_mcu7t5v0__fillcap_4
XFILLER_46_104 VDD VDD VSS VSS gf180mcu_fd_sc_mcu7t5v0__fill_1
XFILLER_46_115 VDD VDD VSS VSS gf180mcu_fd_sc_mcu7t5v0__fill_2
XFILLER_47_627 VDD VDD VSS VSS gf180mcu_fd_sc_mcu7t5v0__fill_2
XFILLER_59_476 VDD VDD VSS VSS gf180mcu_fd_sc_mcu7t5v0__fill_1
XFILLER_74_457 VDD VDD VSS VSS gf180mcu_fd_sc_mcu7t5v0__fillcap_64
XFILLER_74_446 VDD VDD VSS VSS gf180mcu_fd_sc_mcu7t5v0__fillcap_8
XTAP_TAPCELL_ROW_17_508 VDD VSS gf180mcu_fd_sc_mcu7t5v0__filltie
XFILLER_28_874 VDD VDD VSS VSS gf180mcu_fd_sc_mcu7t5v0__fill_1
XFILLER_131_63 VDD VDD VSS VSS gf180mcu_fd_sc_mcu7t5v0__fillcap_4
XFILLER_91_67 VDD VDD VSS VSS gf180mcu_fd_sc_mcu7t5v0__fill_2
XFILLER_42_343 VDD VDD VSS VSS gf180mcu_fd_sc_mcu7t5v0__fillcap_32
XFILLER_30_527 VDD VDD VSS VSS gf180mcu_fd_sc_mcu7t5v0__fillcap_8
XFILLER_42_387 VDD VDD VSS VSS gf180mcu_fd_sc_mcu7t5v0__fillcap_64
XFILLER_128_415 VDD VDD VSS VSS gf180mcu_fd_sc_mcu7t5v0__fill_1
XFILLER_10_251 VDD VDD VSS VSS gf180mcu_fd_sc_mcu7t5v0__fill_2
XFILLER_6_244 VDD VDD VSS VSS gf180mcu_fd_sc_mcu7t5v0__fill_1
XTAP_TAPCELL_ROW_94_1510 VDD VSS gf180mcu_fd_sc_mcu7t5v0__filltie
XFILLER_108_172 VDD VDD VSS VSS gf180mcu_fd_sc_mcu7t5v0__fill_2
XFILLER_123_142 VDD VDD VSS VSS gf180mcu_fd_sc_mcu7t5v0__fillcap_32
XFILLER_69_207 VDD VDD VSS VSS gf180mcu_fd_sc_mcu7t5v0__fill_2
X_2190_ _3746_/Q _3754_/Q _3642_/Q _3650_/Q place79/Z place78/Z _2190_/Z VDD VDD VSS
+ VSS gf180mcu_fd_sc_mcu7t5v0__mux4_1
XFILLER_120_893 VDD VDD VSS VSS gf180mcu_fd_sc_mcu7t5v0__fillcap_8
XFILLER_120_871 VDD VDD VSS VSS gf180mcu_fd_sc_mcu7t5v0__fillcap_4
XFILLER_77_273 VDD VDD VSS VSS gf180mcu_fd_sc_mcu7t5v0__fillcap_4
XFILLER_66_925 VDD VDD VSS VSS gf180mcu_fd_sc_mcu7t5v0__fillcap_8
XFILLER_93_766 VDD VDD VSS VSS gf180mcu_fd_sc_mcu7t5v0__fillcap_4
XFILLER_81_906 VDD VDD VSS VSS gf180mcu_fd_sc_mcu7t5v0__fillcap_4
XFILLER_65_446 VDD VDD VSS VSS gf180mcu_fd_sc_mcu7t5v0__fill_2
XFILLER_92_243 VDD VDD VSS VSS gf180mcu_fd_sc_mcu7t5v0__fill_2
XFILLER_81_928 VDD VDD VSS VSS gf180mcu_fd_sc_mcu7t5v0__fillcap_4
XFILLER_52_107 VDD VDD VSS VSS gf180mcu_fd_sc_mcu7t5v0__fillcap_8
XFILLER_18_384 VDD VDD VSS VSS gf180mcu_fd_sc_mcu7t5v0__fill_1
XFILLER_34_877 VDD VDD VSS VSS gf180mcu_fd_sc_mcu7t5v0__fillcap_8
XFILLER_34_855 VDD VDD VSS VSS gf180mcu_fd_sc_mcu7t5v0__fillcap_4
XTAP_TAPCELL_ROW_44_861 VDD VSS gf180mcu_fd_sc_mcu7t5v0__filltie
XFILLER_60_173 VDD VDD VSS VSS gf180mcu_fd_sc_mcu7t5v0__fill_2
X_3713_ _3713_/D _3740_/CLK _3713_/Q VDD VDD VSS VSS gf180mcu_fd_sc_mcu7t5v0__dffq_1
XTAP_TAPCELL_ROW_132_2013 VDD VSS gf180mcu_fd_sc_mcu7t5v0__filltie
XTAP_TAPCELL_ROW_132_2002 VDD VSS gf180mcu_fd_sc_mcu7t5v0__filltie
X_3644_ _3644_/D _4157_/CLK _3644_/Q VDD VDD VSS VSS gf180mcu_fd_sc_mcu7t5v0__dffq_1
XFILLER_127_470 VDD VDD VSS VSS gf180mcu_fd_sc_mcu7t5v0__fill_1
XFILLER_127_492 VDD VDD VSS VSS gf180mcu_fd_sc_mcu7t5v0__fillcap_16
XFILLER_115_632 VDD VDD VSS VSS gf180mcu_fd_sc_mcu7t5v0__fillcap_8
X_3575_ _3841_/Q _3849_/Q _3857_/Q _3865_/Q place76/Z place75/Z _3575_/Z VDD VDD VSS
+ VSS gf180mcu_fd_sc_mcu7t5v0__mux4_1
XFILLER_115_676 VDD VDD VSS VSS gf180mcu_fd_sc_mcu7t5v0__fillcap_16
XFILLER_114_131 VDD VDD VSS VSS gf180mcu_fd_sc_mcu7t5v0__fill_1
X_2526_ _4068_/Q _3734_/Q _2538_/S _3734_/D VDD VDD VSS VSS gf180mcu_fd_sc_mcu7t5v0__mux2_2
XFILLER_130_613 VDD VDD VSS VSS gf180mcu_fd_sc_mcu7t5v0__fillcap_8
XFILLER_88_527 VDD VDD VSS VSS gf180mcu_fd_sc_mcu7t5v0__fillcap_64
XFILLER_28_104 VDD VDD VSS VSS gf180mcu_fd_sc_mcu7t5v0__fill_1
XFILLER_29_627 VDD VDD VSS VSS gf180mcu_fd_sc_mcu7t5v0__fill_2
XFILLER_110_381 VDD VDD VSS VSS gf180mcu_fd_sc_mcu7t5v0__fillcap_4
X_4127_ _4127_/D _4157_/RN _4127_/CLK _4127_/Q VDD VDD VSS VSS gf180mcu_fd_sc_mcu7t5v0__dffrnq_1
XFILLER_56_424 VDD VDD VSS VSS gf180mcu_fd_sc_mcu7t5v0__fillcap_16
XFILLER_56_457 VDD VDD VSS VSS gf180mcu_fd_sc_mcu7t5v0__fillcap_64
XFILLER_72_928 VDD VDD VSS VSS gf180mcu_fd_sc_mcu7t5v0__fillcap_4
X_4058_ _4058_/D input92/Z _4129_/CLK _4058_/Q VDD VDD VSS VSS gf180mcu_fd_sc_mcu7t5v0__dffrnq_1
XFILLER_71_416 VDD VDD VSS VSS gf180mcu_fd_sc_mcu7t5v0__fillcap_4
XFILLER_25_822 VDD VDD VSS VSS gf180mcu_fd_sc_mcu7t5v0__fillcap_16
XFILLER_25_877 VDD VDD VSS VSS gf180mcu_fd_sc_mcu7t5v0__fill_1
XFILLER_52_663 VDD VDD VSS VSS gf180mcu_fd_sc_mcu7t5v0__fill_2
XTAP_TAPCELL_ROW_65_1133 VDD VSS gf180mcu_fd_sc_mcu7t5v0__filltie
XFILLER_12_527 VDD VDD VSS VSS gf180mcu_fd_sc_mcu7t5v0__fillcap_32
XFILLER_24_387 VDD VDD VSS VSS gf180mcu_fd_sc_mcu7t5v0__fillcap_64
XFILLER_101_88 VDD VDD VSS VSS gf180mcu_fd_sc_mcu7t5v0__fillcap_8
XFILLER_61_48 VDD VDD VSS VSS gf180mcu_fd_sc_mcu7t5v0__fillcap_16
XTAP_TAPCELL_ROW_22_566 VDD VSS gf180mcu_fd_sc_mcu7t5v0__filltie
XTAP_TAPCELL_ROW_22_577 VDD VSS gf180mcu_fd_sc_mcu7t5v0__filltie
XTAP_TAPCELL_ROW_117_1808 VDD VSS gf180mcu_fd_sc_mcu7t5v0__filltie
XPHY_EDGE_ROW_89_Left_222 VDD VSS gf180mcu_fd_sc_mcu7t5v0__endcap
XFILLER_106_643 VDD VDD VSS VSS gf180mcu_fd_sc_mcu7t5v0__fill_1
XFILLER_4_737 VDD VDD VSS VSS gf180mcu_fd_sc_mcu7t5v0__fillcap_64
XFILLER_105_142 VDD VDD VSS VSS gf180mcu_fd_sc_mcu7t5v0__fillcap_16
XTAP_TAPCELL_ROW_76_1273 VDD VSS gf180mcu_fd_sc_mcu7t5v0__filltie
XFILLER_105_164 VDD VDD VSS VSS gf180mcu_fd_sc_mcu7t5v0__fill_1
XFILLER_0_932 VDD VDD VSS VSS gf180mcu_fd_sc_mcu7t5v0__fill_2
XFILLER_121_646 VDD VDD VSS VSS gf180mcu_fd_sc_mcu7t5v0__fillcap_4
XFILLER_105_197 VDD VDD VSS VSS gf180mcu_fd_sc_mcu7t5v0__fillcap_8
XFILLER_94_519 VDD VDD VSS VSS gf180mcu_fd_sc_mcu7t5v0__fillcap_4
XFILLER_19_104 VDD VDD VSS VSS gf180mcu_fd_sc_mcu7t5v0__fillcap_4
XTAP_TAPCELL_ROW_128_1948 VDD VSS gf180mcu_fd_sc_mcu7t5v0__filltie
XFILLER_102_893 VDD VDD VSS VSS gf180mcu_fd_sc_mcu7t5v0__fill_2
XPHY_EDGE_ROW_98_Left_231 VDD VSS gf180mcu_fd_sc_mcu7t5v0__endcap
XFILLER_19_72 VDD VDD VSS VSS gf180mcu_fd_sc_mcu7t5v0__fillcap_32
XFILLER_75_766 VDD VDD VSS VSS gf180mcu_fd_sc_mcu7t5v0__fillcap_4
XFILLER_47_479 VDD VDD VSS VSS gf180mcu_fd_sc_mcu7t5v0__fillcap_4
XFILLER_63_906 VDD VDD VSS VSS gf180mcu_fd_sc_mcu7t5v0__fillcap_4
XFILLER_63_928 VDD VDD VSS VSS gf180mcu_fd_sc_mcu7t5v0__fillcap_4
XFILLER_90_725 VDD VDD VSS VSS gf180mcu_fd_sc_mcu7t5v0__fillcap_8
XFILLER_34_107 VDD VDD VSS VSS gf180mcu_fd_sc_mcu7t5v0__fillcap_32
XFILLER_90_769 VDD VDD VSS VSS gf180mcu_fd_sc_mcu7t5v0__fillcap_32
XFILLER_16_877 VDD VDD VSS VSS gf180mcu_fd_sc_mcu7t5v0__fill_1
Xclkbuf_leaf_54_clk clkload0/I _3866_/CLK VDD VDD VSS VSS gf180mcu_fd_sc_mcu7t5v0__clkbuf_8
XFILLER_30_313 VDD VDD VSS VSS gf180mcu_fd_sc_mcu7t5v0__fill_2
XFILLER_70_471 VDD VDD VSS VSS gf180mcu_fd_sc_mcu7t5v0__fill_1
XFILLER_129_702 VDD VDD VSS VSS gf180mcu_fd_sc_mcu7t5v0__fillcap_4
XTAP_TAPCELL_ROW_41_820 VDD VSS gf180mcu_fd_sc_mcu7t5v0__filltie
XFILLER_129_768 VDD VDD VSS VSS gf180mcu_fd_sc_mcu7t5v0__fill_2
XFILLER_128_223 VDD VDD VSS VSS gf180mcu_fd_sc_mcu7t5v0__fillcap_16
XFILLER_7_542 VDD VDD VSS VSS gf180mcu_fd_sc_mcu7t5v0__fill_1
XFILLER_116_429 VDD VDD VSS VSS gf180mcu_fd_sc_mcu7t5v0__fillcap_16
XFILLER_109_492 VDD VDD VSS VSS gf180mcu_fd_sc_mcu7t5v0__fillcap_8
XFILLER_109_481 VDD VDD VSS VSS gf180mcu_fd_sc_mcu7t5v0__fillcap_8
XFILLER_124_451 VDD VDD VSS VSS gf180mcu_fd_sc_mcu7t5v0__fillcap_4
X_3360_ _4081_/Q _3316_/Z _3361_/A2 VDD VDD VSS VSS gf180mcu_fd_sc_mcu7t5v0__nor2_1
XFILLER_98_847 VDD VDD VSS VSS gf180mcu_fd_sc_mcu7t5v0__fillcap_16
X_2311_ _3640_/Q place81/Z _2319_/S _3640_/D VDD VDD VSS VSS gf180mcu_fd_sc_mcu7t5v0__mux2_2
X_3291_ _3904_/Q _4160_/Q _3292_/A2 VDD VDD VSS VSS gf180mcu_fd_sc_mcu7t5v0__nand2_1
X_2242_ _3900_/Q place68/Z place63/Z _3948_/Q _3916_/Q place72/Z _2243_/I VDD VDD
+ VSS VSS gf180mcu_fd_sc_mcu7t5v0__aoi222_1
XFILLER_78_593 VDD VDD VSS VSS gf180mcu_fd_sc_mcu7t5v0__fill_2
XFILLER_18_2 VDD VDD VSS VSS gf180mcu_fd_sc_mcu7t5v0__fillcap_16
XFILLER_38_435 VDD VDD VSS VSS gf180mcu_fd_sc_mcu7t5v0__fillcap_4
XTAP_TAPCELL_ROW_49_920 VDD VSS gf180mcu_fd_sc_mcu7t5v0__filltie
X_2173_ _3745_/Q _3753_/Q _3641_/Q _3649_/Q place79/Z place78/Z _2173_/Z VDD VDD VSS
+ VSS gf180mcu_fd_sc_mcu7t5v0__mux4_1
XFILLER_38_457 VDD VDD VSS VSS gf180mcu_fd_sc_mcu7t5v0__fillcap_16
XFILLER_54_928 VDD VDD VSS VSS gf180mcu_fd_sc_mcu7t5v0__fillcap_4
XFILLER_19_671 VDD VDD VSS VSS gf180mcu_fd_sc_mcu7t5v0__fill_1
XFILLER_65_276 VDD VDD VSS VSS gf180mcu_fd_sc_mcu7t5v0__fillcap_4
XFILLER_81_758 VDD VDD VSS VSS gf180mcu_fd_sc_mcu7t5v0__fillcap_8
Xclkbuf_leaf_45_clk clkload3/I _4163_/CLK VDD VDD VSS VSS gf180mcu_fd_sc_mcu7t5v0__clkbuf_8
XFILLER_80_279 VDD VDD VSS VSS gf180mcu_fd_sc_mcu7t5v0__fillcap_4
XFILLER_22_803 VDD VDD VSS VSS gf180mcu_fd_sc_mcu7t5v0__fill_2
XFILLER_21_346 VDD VDD VSS VSS gf180mcu_fd_sc_mcu7t5v0__fillcap_4
XFILLER_119_212 VDD VDD VSS VSS gf180mcu_fd_sc_mcu7t5v0__fillcap_16
X_1957_ _3607_/A2 _3280_/A2 place64/I VDD VDD VSS VSS gf180mcu_fd_sc_mcu7t5v0__nor2_1
XFILLER_31_18 VDD VDD VSS VSS gf180mcu_fd_sc_mcu7t5v0__fillcap_8
XTAP_TAPCELL_ROW_60_1063 VDD VSS gf180mcu_fd_sc_mcu7t5v0__filltie
X_1888_ _3889_/Q _3890_/Q _1888_/B _3891_/Q _1889_/B VDD VDD VSS VSS gf180mcu_fd_sc_mcu7t5v0__oai211_1
X_3627_ _4167_/Q _3627_/I1 _3627_/S _4167_/D VDD VDD VSS VSS gf180mcu_fd_sc_mcu7t5v0__mux2_2
X_3558_ _3557_/Z _4150_/Q _3600_/S _4150_/D VDD VDD VSS VSS gf180mcu_fd_sc_mcu7t5v0__mux2_2
XTAP_TAPCELL_ROW_112_1738 VDD VSS gf180mcu_fd_sc_mcu7t5v0__filltie
XFILLER_89_858 VDD VDD VSS VSS gf180mcu_fd_sc_mcu7t5v0__fillcap_8
XFILLER_0_206 VDD VDD VSS VSS gf180mcu_fd_sc_mcu7t5v0__fillcap_32
X_2509_ _3726_/Q _4068_/Q _2521_/S _3726_/D VDD VDD VSS VSS gf180mcu_fd_sc_mcu7t5v0__mux2_2
Xinput107 hold215/Z _3242_/A2 VDD VDD VSS VSS gf180mcu_fd_sc_mcu7t5v0__dlyb_1
XFILLER_102_123 VDD VDD VSS VSS gf180mcu_fd_sc_mcu7t5v0__fillcap_4
Xinput118 hold221/Z _3133_/I1 VDD VDD VSS VSS gf180mcu_fd_sc_mcu7t5v0__dlyb_1
X_3489_ _3904_/Q place91/Z _4154_/Q _3490_/A3 VDD VDD VSS VSS gf180mcu_fd_sc_mcu7t5v0__oai21_1
Xinput129 hold193/Z _3154_/I1 VDD VDD VSS VSS gf180mcu_fd_sc_mcu7t5v0__dlyb_1
XFILLER_88_379 VDD VDD VSS VSS gf180mcu_fd_sc_mcu7t5v0__fillcap_4
XFILLER_29_424 VDD VDD VSS VSS gf180mcu_fd_sc_mcu7t5v0__fill_1
XFILLER_56_37 VDD VDD VSS VSS gf180mcu_fd_sc_mcu7t5v0__fillcap_64
XFILLER_84_552 VDD VDD VSS VSS gf180mcu_fd_sc_mcu7t5v0__fill_1
XFILLER_45_906 VDD VDD VSS VSS gf180mcu_fd_sc_mcu7t5v0__fillcap_4
XFILLER_45_928 VDD VDD VSS VSS gf180mcu_fd_sc_mcu7t5v0__fillcap_4
XFILLER_16_107 VDD VDD VSS VSS gf180mcu_fd_sc_mcu7t5v0__fillcap_16
XTAP_TAPCELL_ROW_27_636 VDD VSS gf180mcu_fd_sc_mcu7t5v0__filltie
Xclkbuf_leaf_36_clk clkload3/I _4157_/CLK VDD VDD VSS VSS gf180mcu_fd_sc_mcu7t5v0__clkbuf_8
XFILLER_71_257 VDD VDD VSS VSS gf180mcu_fd_sc_mcu7t5v0__fillcap_4
XTAP_TAPCELL_ROW_123_1889 VDD VSS gf180mcu_fd_sc_mcu7t5v0__filltie
XFILLER_13_836 VDD VDD VSS VSS gf180mcu_fd_sc_mcu7t5v0__fillcap_4
XFILLER_25_696 VDD VDD VSS VSS gf180mcu_fd_sc_mcu7t5v0__fillcap_4
XFILLER_8_317 VDD VDD VSS VSS gf180mcu_fd_sc_mcu7t5v0__fillcap_64
XTAP_TAPCELL_ROW_78_1302 VDD VSS gf180mcu_fd_sc_mcu7t5v0__filltie
XFILLER_106_451 VDD VDD VSS VSS gf180mcu_fd_sc_mcu7t5v0__fillcap_4
XFILLER_4_567 VDD VDD VSS VSS gf180mcu_fd_sc_mcu7t5v0__fillcap_16
XFILLER_106_473 VDD VDD VSS VSS gf180mcu_fd_sc_mcu7t5v0__fillcap_8
XFILLER_79_324 VDD VDD VSS VSS gf180mcu_fd_sc_mcu7t5v0__fillcap_8
XFILLER_97_88 VDD VDD VSS VSS gf180mcu_fd_sc_mcu7t5v0__fillcap_8
XTAP_TAPCELL_ROW_7_383 VDD VSS gf180mcu_fd_sc_mcu7t5v0__filltie
XTAP_TAPCELL_ROW_7_372 VDD VSS gf180mcu_fd_sc_mcu7t5v0__filltie
XFILLER_0_784 VDD VDD VSS VSS gf180mcu_fd_sc_mcu7t5v0__fillcap_32
XTAP_TAPCELL_ROW_89_1442 VDD VSS gf180mcu_fd_sc_mcu7t5v0__filltie
XFILLER_90_522 VDD VDD VSS VSS gf180mcu_fd_sc_mcu7t5v0__fill_2
XFILLER_35_438 VDD VDD VSS VSS gf180mcu_fd_sc_mcu7t5v0__fill_1
XFILLER_63_725 VDD VDD VSS VSS gf180mcu_fd_sc_mcu7t5v0__fillcap_4
Xclkbuf_leaf_27_clk clkload6/I _4128_/CLK VDD VDD VSS VSS gf180mcu_fd_sc_mcu7t5v0__clkbuf_8
XFILLER_63_758 VDD VDD VSS VSS gf180mcu_fd_sc_mcu7t5v0__fillcap_8
X_1811_ _3899_/Q _1942_/B _1934_/I1 VDD VDD VSS VSS gf180mcu_fd_sc_mcu7t5v0__nor2_1
X_2791_ place87/Z _3848_/Q _2799_/S _3848_/D VDD VDD VSS VSS gf180mcu_fd_sc_mcu7t5v0__mux2_2
XFILLER_31_688 VDD VDD VSS VSS gf180mcu_fd_sc_mcu7t5v0__fillcap_8
XFILLER_124_270 VDD VDD VSS VSS gf180mcu_fd_sc_mcu7t5v0__fillcap_32
X_3343_ _4078_/Q _3347_/B _3344_/B VDD VDD VSS VSS gf180mcu_fd_sc_mcu7t5v0__nand2_1
XFILLER_98_688 VDD VDD VSS VSS gf180mcu_fd_sc_mcu7t5v0__fillcap_4
XFILLER_86_839 VDD VDD VSS VSS gf180mcu_fd_sc_mcu7t5v0__fillcap_4
X_3274_ _4064_/Q _3274_/A2 _3274_/B _3276_/A2 VDD VDD VSS VSS gf180mcu_fd_sc_mcu7t5v0__aoi21_1
XFILLER_85_349 VDD VDD VSS VSS gf180mcu_fd_sc_mcu7t5v0__fill_1
XFILLER_27_928 VDD VDD VSS VSS gf180mcu_fd_sc_mcu7t5v0__fillcap_4
XFILLER_39_788 VDD VDD VSS VSS gf180mcu_fd_sc_mcu7t5v0__fillcap_4
X_2156_ _2156_/A1 _2156_/A2 _2156_/A3 _2156_/ZN VDD VDD VSS VSS gf180mcu_fd_sc_mcu7t5v0__nand3_1
X_2087_ place71/Z place52/Z _2085_/Z _2088_/B VDD VDD VSS VSS gf180mcu_fd_sc_mcu7t5v0__nand3_1
Xclkbuf_leaf_18_clk clkload2/I _3946_/CLK VDD VDD VSS VSS gf180mcu_fd_sc_mcu7t5v0__clkbuf_8
XPHY_EDGE_ROW_5_Right_5 VDD VSS gf180mcu_fd_sc_mcu7t5v0__endcap
XTAP_TAPCELL_ROW_52_959 VDD VSS gf180mcu_fd_sc_mcu7t5v0__filltie
XFILLER_61_290 VDD VDD VSS VSS gf180mcu_fd_sc_mcu7t5v0__fill_1
X_2989_ _3939_/Q place84/Z _3041_/S _3939_/D VDD VDD VSS VSS gf180mcu_fd_sc_mcu7t5v0__mux2_2
XFILLER_107_248 VDD VDD VSS VSS gf180mcu_fd_sc_mcu7t5v0__fill_2
XFILLER_104_933 VDD VDD VSS VSS gf180mcu_fd_sc_mcu7t5v0__fill_1
XTAP_TAPCELL_ROW_73_1232 VDD VSS gf180mcu_fd_sc_mcu7t5v0__filltie
XFILLER_89_666 VDD VDD VSS VSS gf180mcu_fd_sc_mcu7t5v0__fill_1
XFILLER_89_699 VDD VDD VSS VSS gf180mcu_fd_sc_mcu7t5v0__fill_1
XFILLER_77_839 VDD VDD VSS VSS gf180mcu_fd_sc_mcu7t5v0__fill_1
XTAP_TAPCELL_ROW_4_342 VDD VSS gf180mcu_fd_sc_mcu7t5v0__filltie
XFILLER_67_58 VDD VDD VSS VSS gf180mcu_fd_sc_mcu7t5v0__fillcap_8
XTAP_TAPCELL_ROW_125_1907 VDD VSS gf180mcu_fd_sc_mcu7t5v0__filltie
XFILLER_123_42 VDD VDD VSS VSS gf180mcu_fd_sc_mcu7t5v0__fillcap_16
XFILLER_85_850 VDD VDD VSS VSS gf180mcu_fd_sc_mcu7t5v0__fillcap_4
XFILLER_84_360 VDD VDD VSS VSS gf180mcu_fd_sc_mcu7t5v0__fillcap_16
XFILLER_17_416 VDD VDD VSS VSS gf180mcu_fd_sc_mcu7t5v0__fillcap_4
XFILLER_29_276 VDD VDD VSS VSS gf180mcu_fd_sc_mcu7t5v0__fillcap_4
XFILLER_33_909 VDD VDD VSS VSS gf180mcu_fd_sc_mcu7t5v0__fill_1
XFILLER_16_51 VDD VDD VSS VSS gf180mcu_fd_sc_mcu7t5v0__fill_1
XFILLER_44_257 VDD VDD VSS VSS gf180mcu_fd_sc_mcu7t5v0__fillcap_8
XTAP_TAPCELL_ROW_84_1383 VDD VSS gf180mcu_fd_sc_mcu7t5v0__filltie
XTAP_TAPCELL_ROW_84_1372 VDD VSS gf180mcu_fd_sc_mcu7t5v0__filltie
XFILLER_9_626 VDD VDD VSS VSS gf180mcu_fd_sc_mcu7t5v0__fillcap_4
XFILLER_13_688 VDD VDD VSS VSS gf180mcu_fd_sc_mcu7t5v0__fill_2
XFILLER_126_579 VDD VDD VSS VSS gf180mcu_fd_sc_mcu7t5v0__fill_1
XFILLER_126_546 VDD VDD VSS VSS gf180mcu_fd_sc_mcu7t5v0__fill_1
XPHY_EDGE_ROW_26_Left_159 VDD VSS gf180mcu_fd_sc_mcu7t5v0__endcap
XFILLER_79_154 VDD VDD VSS VSS gf180mcu_fd_sc_mcu7t5v0__fill_2
XFILLER_63_500 VDD VDD VSS VSS gf180mcu_fd_sc_mcu7t5v0__fillcap_4
XFILLER_91_842 VDD VDD VSS VSS gf180mcu_fd_sc_mcu7t5v0__fillcap_64
X_3961_ _3961_/D _2279_/I _4125_/CLK _3961_/Q VDD VDD VSS VSS gf180mcu_fd_sc_mcu7t5v0__dffrnq_1
XPHY_EDGE_ROW_35_Left_168 VDD VSS gf180mcu_fd_sc_mcu7t5v0__endcap
XFILLER_35_279 VDD VDD VSS VSS gf180mcu_fd_sc_mcu7t5v0__fill_1
XFILLER_32_931 VDD VDD VSS VSS gf180mcu_fd_sc_mcu7t5v0__fill_2
X_2912_ place88/Z _3903_/Q _2972_/S _3903_/D VDD VDD VSS VSS gf180mcu_fd_sc_mcu7t5v0__mux2_2
X_3892_ _3892_/D _4157_/RN _4127_/CLK _3892_/Q VDD VDD VSS VSS gf180mcu_fd_sc_mcu7t5v0__dffrnq_1
XFILLER_129_340 VDD VDD VSS VSS gf180mcu_fd_sc_mcu7t5v0__fill_1
X_2774_ place87/Z _3840_/Q _2782_/S _3840_/D VDD VDD VSS VSS gf180mcu_fd_sc_mcu7t5v0__mux2_2
XFILLER_117_557 VDD VDD VSS VSS gf180mcu_fd_sc_mcu7t5v0__fill_2
XPHY_EDGE_ROW_44_Left_177 VDD VSS gf180mcu_fd_sc_mcu7t5v0__endcap
Xclkbuf_leaf_7_clk clkload2/I _4115_/CLK VDD VDD VSS VSS gf180mcu_fd_sc_mcu7t5v0__clkbuf_8
XFILLER_113_730 VDD VDD VSS VSS gf180mcu_fd_sc_mcu7t5v0__fill_2
X_3326_ _3326_/A1 _3326_/A2 _3326_/B1 _3338_/A1 _4075_/D VDD VDD VSS VSS gf180mcu_fd_sc_mcu7t5v0__aoi22_2
XFILLER_100_457 VDD VDD VSS VSS gf180mcu_fd_sc_mcu7t5v0__fillcap_32
XFILLER_39_552 VDD VDD VSS VSS gf180mcu_fd_sc_mcu7t5v0__fill_2
X_3257_ _4078_/Q _4080_/Q _3342_/B VDD VDD VSS VSS gf180mcu_fd_sc_mcu7t5v0__nor2_1
X_3188_ _4033_/Q _4001_/Q _4129_/D _4033_/D VDD VDD VSS VSS gf180mcu_fd_sc_mcu7t5v0__mux2_2
X_2208_ _2208_/A1 _2208_/A2 _2208_/A3 _2208_/ZN VDD VDD VSS VSS gf180mcu_fd_sc_mcu7t5v0__nand3_1
XTAP_TAPCELL_ROW_1_301 VDD VSS gf180mcu_fd_sc_mcu7t5v0__filltie
XFILLER_26_213 VDD VDD VSS VSS gf180mcu_fd_sc_mcu7t5v0__fill_2
XFILLER_54_522 VDD VDD VSS VSS gf180mcu_fd_sc_mcu7t5v0__fill_2
X_2139_ _4125_/Q _2167_/A2 _2138_/Z _2185_/A1 _2140_/A2 VDD VDD VSS VSS gf180mcu_fd_sc_mcu7t5v0__aoi22_1
XPHY_EDGE_ROW_53_Left_186 VDD VSS gf180mcu_fd_sc_mcu7t5v0__endcap
XFILLER_81_352 VDD VDD VSS VSS gf180mcu_fd_sc_mcu7t5v0__fillcap_64
XTAP_TAPCELL_ROW_37_764 VDD VSS gf180mcu_fd_sc_mcu7t5v0__filltie
XFILLER_41_205 VDD VDD VSS VSS gf180mcu_fd_sc_mcu7t5v0__fillcap_4
XTAP_TAPCELL_ROW_120_1848 VDD VSS gf180mcu_fd_sc_mcu7t5v0__filltie
XFILLER_10_647 VDD VDD VSS VSS gf180mcu_fd_sc_mcu7t5v0__fillcap_4
XTAP_TAPCELL_ROW_9_401 VDD VSS gf180mcu_fd_sc_mcu7t5v0__filltie
XFILLER_5_139 VDD VDD VSS VSS gf180mcu_fd_sc_mcu7t5v0__fill_1
XPHY_EDGE_ROW_62_Left_195 VDD VSS gf180mcu_fd_sc_mcu7t5v0__endcap
XFILLER_118_53 VDD VDD VSS VSS gf180mcu_fd_sc_mcu7t5v0__fillcap_4
XTAP_TAPCELL_ROW_131_1988 VDD VSS gf180mcu_fd_sc_mcu7t5v0__filltie
XFILLER_76_102 VDD VDD VSS VSS gf180mcu_fd_sc_mcu7t5v0__fill_2
XFILLER_58_861 VDD VDD VSS VSS gf180mcu_fd_sc_mcu7t5v0__fill_2
XTAP_TAPCELL_ROW_86_1401 VDD VSS gf180mcu_fd_sc_mcu7t5v0__filltie
XFILLER_45_500 VDD VDD VSS VSS gf180mcu_fd_sc_mcu7t5v0__fillcap_4
XFILLER_58_872 VDD VDD VSS VSS gf180mcu_fd_sc_mcu7t5v0__fill_2
XFILLER_73_842 VDD VDD VSS VSS gf180mcu_fd_sc_mcu7t5v0__fillcap_64
XFILLER_27_72 VDD VDD VSS VSS gf180mcu_fd_sc_mcu7t5v0__fillcap_8
XFILLER_45_566 VDD VDD VSS VSS gf180mcu_fd_sc_mcu7t5v0__fill_2
XFILLER_14_931 VDD VDD VSS VSS gf180mcu_fd_sc_mcu7t5v0__fill_2
XFILLER_41_772 VDD VDD VSS VSS gf180mcu_fd_sc_mcu7t5v0__fillcap_64
XTAP_TAPCELL_ROW_97_1541 VDD VSS gf180mcu_fd_sc_mcu7t5v0__filltie
XTAP_TAPCELL_ROW_97_1552 VDD VSS gf180mcu_fd_sc_mcu7t5v0__filltie
XFILLER_126_387 VDD VDD VSS VSS gf180mcu_fd_sc_mcu7t5v0__fillcap_64
XFILLER_114_527 VDD VDD VSS VSS gf180mcu_fd_sc_mcu7t5v0__fillcap_64
XFILLER_114_516 VDD VDD VSS VSS gf180mcu_fd_sc_mcu7t5v0__fillcap_8
XFILLER_114_505 VDD VDD VSS VSS gf180mcu_fd_sc_mcu7t5v0__fill_2
XFILLER_99_205 VDD VDD VSS VSS gf180mcu_fd_sc_mcu7t5v0__fillcap_4
XFILLER_95_400 VDD VDD VSS VSS gf180mcu_fd_sc_mcu7t5v0__fillcap_4
X_4160_ _4160_/D input92/Z _4167_/CLK _4160_/Q VDD VDD VSS VSS gf180mcu_fd_sc_mcu7t5v0__dffrnq_1
XFILLER_95_422 VDD VDD VSS VSS gf180mcu_fd_sc_mcu7t5v0__fillcap_16
X_4091_ _4091_/D _2279_/I _4094_/CLK _4091_/Q VDD VDD VSS VSS gf180mcu_fd_sc_mcu7t5v0__dffrnq_2
XFILLER_95_488 VDD VDD VSS VSS gf180mcu_fd_sc_mcu7t5v0__fill_2
XFILLER_51_514 VDD VDD VSS VSS gf180mcu_fd_sc_mcu7t5v0__fillcap_32
XFILLER_63_341 VDD VDD VSS VSS gf180mcu_fd_sc_mcu7t5v0__fillcap_8
XFILLER_63_352 VDD VDD VSS VSS gf180mcu_fd_sc_mcu7t5v0__fillcap_4
XTAP_TAPCELL_ROW_106_1670 VDD VSS gf180mcu_fd_sc_mcu7t5v0__filltie
XFILLER_17_780 VDD VDD VSS VSS gf180mcu_fd_sc_mcu7t5v0__fill_2
XTAP_TAPCELL_ROW_34_723 VDD VSS gf180mcu_fd_sc_mcu7t5v0__filltie
XTAP_TAPCELL_ROW_34_734 VDD VSS gf180mcu_fd_sc_mcu7t5v0__filltie
X_3944_ _3944_/D _4157_/RN _3976_/CLK _3944_/Q VDD VDD VSS VSS gf180mcu_fd_sc_mcu7t5v0__dffrnq_1
XFILLER_51_558 VDD VDD VSS VSS gf180mcu_fd_sc_mcu7t5v0__fill_2
X_3875_ _3875_/D _3877_/CLK _3875_/Q VDD VDD VSS VSS gf180mcu_fd_sc_mcu7t5v0__dffq_1
XFILLER_31_282 VDD VDD VSS VSS gf180mcu_fd_sc_mcu7t5v0__fillcap_16
XFILLER_118_877 VDD VDD VSS VSS gf180mcu_fd_sc_mcu7t5v0__fillcap_16
XTAP_TAPCELL_ROW_57_1024 VDD VSS gf180mcu_fd_sc_mcu7t5v0__filltie
XFILLER_87_912 VDD VDD VSS VSS gf180mcu_fd_sc_mcu7t5v0__fillcap_16
XTAP_TAPCELL_ROW_70_1202 VDD VSS gf180mcu_fd_sc_mcu7t5v0__filltie
XFILLER_98_282 VDD VDD VSS VSS gf180mcu_fd_sc_mcu7t5v0__fill_1
XFILLER_58_113 VDD VDD VSS VSS gf180mcu_fd_sc_mcu7t5v0__fill_1
XFILLER_101_766 VDD VDD VSS VSS gf180mcu_fd_sc_mcu7t5v0__fillcap_4
X_3309_ _4073_/Q _4167_/Q _4157_/D _4073_/D VDD VDD VSS VSS gf180mcu_fd_sc_mcu7t5v0__mux2_2
XFILLER_101_788 VDD VDD VSS VSS gf180mcu_fd_sc_mcu7t5v0__fillcap_8
XFILLER_100_254 VDD VDD VSS VSS gf180mcu_fd_sc_mcu7t5v0__fillcap_8
XFILLER_55_842 VDD VDD VSS VSS gf180mcu_fd_sc_mcu7t5v0__fillcap_64
XFILLER_64_37 VDD VDD VSS VSS gf180mcu_fd_sc_mcu7t5v0__fillcap_8
XTAP_TAPCELL_ROW_68_1164 VDD VSS gf180mcu_fd_sc_mcu7t5v0__filltie
XFILLER_70_801 VDD VDD VSS VSS gf180mcu_fd_sc_mcu7t5v0__fillcap_4
XFILLER_120_10 VDD VDD VSS VSS gf180mcu_fd_sc_mcu7t5v0__fill_2
XTAP_TAPCELL_ROW_68_1175 VDD VSS gf180mcu_fd_sc_mcu7t5v0__filltie
XTAP_TAPCELL_ROW_81_1342 VDD VSS gf180mcu_fd_sc_mcu7t5v0__filltie
XFILLER_11_912 VDD VDD VSS VSS gf180mcu_fd_sc_mcu7t5v0__fillcap_16
XTAP_TAPCELL_ROW_12_439 VDD VSS gf180mcu_fd_sc_mcu7t5v0__filltie
XFILLER_6_415 VDD VDD VSS VSS gf180mcu_fd_sc_mcu7t5v0__fillcap_32
XPHY_EDGE_ROW_70_Left_203 VDD VSS gf180mcu_fd_sc_mcu7t5v0__endcap
XFILLER_109_899 VDD VDD VSS VSS gf180mcu_fd_sc_mcu7t5v0__fillcap_8
XFILLER_123_346 VDD VDD VSS VSS gf180mcu_fd_sc_mcu7t5v0__fillcap_4
XFILLER_2_621 VDD VDD VSS VSS gf180mcu_fd_sc_mcu7t5v0__fill_2
XFILLER_2_632 VDD VDD VSS VSS gf180mcu_fd_sc_mcu7t5v0__fillcap_32
XFILLER_96_219 VDD VDD VSS VSS gf180mcu_fd_sc_mcu7t5v0__fill_1
XFILLER_1_142 VDD VDD VSS VSS gf180mcu_fd_sc_mcu7t5v0__fillcap_32
XTAP_TAPCELL_ROW_92_1482 VDD VSS gf180mcu_fd_sc_mcu7t5v0__filltie
XFILLER_89_282 VDD VDD VSS VSS gf180mcu_fd_sc_mcu7t5v0__fillcap_32
XFILLER_77_422 VDD VDD VSS VSS gf180mcu_fd_sc_mcu7t5v0__fillcap_32
XFILLER_2_687 VDD VDD VSS VSS gf180mcu_fd_sc_mcu7t5v0__fill_1
XFILLER_92_403 VDD VDD VSS VSS gf180mcu_fd_sc_mcu7t5v0__fillcap_4
XFILLER_77_488 VDD VDD VSS VSS gf180mcu_fd_sc_mcu7t5v0__fill_2
XFILLER_45_352 VDD VDD VSS VSS gf180mcu_fd_sc_mcu7t5v0__fillcap_16
XFILLER_61_823 VDD VDD VSS VSS gf180mcu_fd_sc_mcu7t5v0__fill_1
X_1990_ _4085_/Q _4086_/Q _4088_/Q _4087_/Q _3394_/A3 VDD VDD VSS VSS gf180mcu_fd_sc_mcu7t5v0__nor4_4
XFILLER_72_193 VDD VDD VSS VSS gf180mcu_fd_sc_mcu7t5v0__fillcap_8
XPHY_EDGE_ROW_109_Left_242 VDD VSS gf180mcu_fd_sc_mcu7t5v0__endcap
XFILLER_119_619 VDD VDD VSS VSS gf180mcu_fd_sc_mcu7t5v0__fillcap_8
XFILLER_13_282 VDD VDD VSS VSS gf180mcu_fd_sc_mcu7t5v0__fillcap_64
XFILLER_118_107 VDD VDD VSS VSS gf180mcu_fd_sc_mcu7t5v0__fillcap_64
X_3660_ _3660_/D _4167_/CLK _3660_/Q VDD VDD VSS VSS gf180mcu_fd_sc_mcu7t5v0__dffq_1
Xclkload23 _4136_/CLK clkload23/Z VDD VDD VSS VSS gf180mcu_fd_sc_mcu7t5v0__clkbuf_2
Xclkload34 _4163_/CLK clkload34/Z VDD VDD VSS VSS gf180mcu_fd_sc_mcu7t5v0__clkbuf_2
X_3591_ _3787_/Q _3795_/Q _3803_/Q _3811_/Q place76/Z place75/Z _3591_/Z VDD VDD VSS
+ VSS gf180mcu_fd_sc_mcu7t5v0__mux4_1
Xclkload12 _4123_/CLK clkload12/Z VDD VDD VSS VSS gf180mcu_fd_sc_mcu7t5v0__clkbuf_8
X_2611_ place87/Z _3768_/Q _2619_/S _3768_/D VDD VDD VSS VSS gf180mcu_fd_sc_mcu7t5v0__mux2_2
Xclkload45 _4092_/CLK clkload45/ZN VDD VDD VSS VSS gf180mcu_fd_sc_mcu7t5v0__inv_2
X_2542_ _3741_/Q place82/Z _2556_/S _3741_/D VDD VDD VSS VSS gf180mcu_fd_sc_mcu7t5v0__mux2_2
XFILLER_115_836 VDD VDD VSS VSS gf180mcu_fd_sc_mcu7t5v0__fillcap_4
X_2473_ _3710_/Q _4068_/Q _2485_/S _3710_/D VDD VDD VSS VSS gf180mcu_fd_sc_mcu7t5v0__mux2_2
XFILLER_48_2 VDD VDD VSS VSS gf180mcu_fd_sc_mcu7t5v0__fillcap_32
XFILLER_69_912 VDD VDD VSS VSS gf180mcu_fd_sc_mcu7t5v0__fillcap_16
XPHY_EDGE_ROW_118_Left_251 VDD VSS gf180mcu_fd_sc_mcu7t5v0__endcap
X_4143_ _4143_/D _4148_/RN _4145_/CLK _4143_/Q VDD VDD VSS VSS gf180mcu_fd_sc_mcu7t5v0__dffrnq_1
XFILLER_83_414 VDD VDD VSS VSS gf180mcu_fd_sc_mcu7t5v0__fillcap_4
X_4074_ _4074_/D input92/Z _4167_/CLK _4074_/Q VDD VDD VSS VSS gf180mcu_fd_sc_mcu7t5v0__dffrnq_1
XFILLER_28_308 VDD VDD VSS VSS gf180mcu_fd_sc_mcu7t5v0__fillcap_4
X_3025_ _3956_/Q _4044_/Q _3041_/S _3956_/D VDD VDD VSS VSS gf180mcu_fd_sc_mcu7t5v0__mux2_2
XFILLER_64_661 VDD VDD VSS VSS gf180mcu_fd_sc_mcu7t5v0__fillcap_4
XFILLER_91_480 VDD VDD VSS VSS gf180mcu_fd_sc_mcu7t5v0__fillcap_8
XTAP_TAPCELL_ROW_47_892 VDD VSS gf180mcu_fd_sc_mcu7t5v0__filltie
XPHY_EDGE_ROW_127_Left_260 VDD VSS gf180mcu_fd_sc_mcu7t5v0__endcap
XFILLER_12_709 VDD VDD VSS VSS gf180mcu_fd_sc_mcu7t5v0__fillcap_16
X_3927_ _3927_/D _2279_/I _3968_/CLK _3927_/Q VDD VDD VSS VSS gf180mcu_fd_sc_mcu7t5v0__dffrnq_1
XFILLER_32_591 VDD VDD VSS VSS gf180mcu_fd_sc_mcu7t5v0__fillcap_4
Xclkload6 clkload6/I clkload6/Z VDD VDD VSS VSS gf180mcu_fd_sc_mcu7t5v0__clkbuf_8
X_3858_ _3858_/D _4123_/CLK _3858_/Q VDD VDD VSS VSS gf180mcu_fd_sc_mcu7t5v0__dffq_1
X_3789_ _3789_/D _3806_/CLK _3789_/Q VDD VDD VSS VSS gf180mcu_fd_sc_mcu7t5v0__dffq_1
XFILLER_117_162 VDD VDD VSS VSS gf180mcu_fd_sc_mcu7t5v0__fill_2
XFILLER_59_422 VDD VDD VSS VSS gf180mcu_fd_sc_mcu7t5v0__fillcap_4
XFILLER_86_263 VDD VDD VSS VSS gf180mcu_fd_sc_mcu7t5v0__fillcap_8
XFILLER_74_403 VDD VDD VSS VSS gf180mcu_fd_sc_mcu7t5v0__fillcap_8
XFILLER_75_69 VDD VDD VSS VSS gf180mcu_fd_sc_mcu7t5v0__fill_1
XFILLER_59_499 VDD VDD VSS VSS gf180mcu_fd_sc_mcu7t5v0__fillcap_32
XFILLER_131_42 VDD VDD VSS VSS gf180mcu_fd_sc_mcu7t5v0__fillcap_4
XTAP_TAPCELL_ROW_17_509 VDD VSS gf180mcu_fd_sc_mcu7t5v0__filltie
XFILLER_27_352 VDD VDD VSS VSS gf180mcu_fd_sc_mcu7t5v0__fill_2
XFILLER_55_650 VDD VDD VSS VSS gf180mcu_fd_sc_mcu7t5v0__fill_1
XFILLER_42_311 VDD VDD VSS VSS gf180mcu_fd_sc_mcu7t5v0__fillcap_4
XFILLER_15_558 VDD VDD VSS VSS gf180mcu_fd_sc_mcu7t5v0__fill_2
XFILLER_54_193 VDD VDD VSS VSS gf180mcu_fd_sc_mcu7t5v0__fillcap_4
XFILLER_70_664 VDD VDD VSS VSS gf180mcu_fd_sc_mcu7t5v0__fill_1
XFILLER_129_928 VDD VDD VSS VSS gf180mcu_fd_sc_mcu7t5v0__fillcap_4
XFILLER_10_241 VDD VDD VSS VSS gf180mcu_fd_sc_mcu7t5v0__fillcap_4
XFILLER_7_702 VDD VDD VSS VSS gf180mcu_fd_sc_mcu7t5v0__fillcap_64
XFILLER_24_95 VDD VDD VSS VSS gf180mcu_fd_sc_mcu7t5v0__fillcap_8
XTAP_TAPCELL_ROW_94_1511 VDD VSS gf180mcu_fd_sc_mcu7t5v0__filltie
XFILLER_109_696 VDD VDD VSS VSS gf180mcu_fd_sc_mcu7t5v0__fillcap_4
XFILLER_108_195 VDD VDD VSS VSS gf180mcu_fd_sc_mcu7t5v0__fill_1
XFILLER_78_731 VDD VDD VSS VSS gf180mcu_fd_sc_mcu7t5v0__fillcap_4
XFILLER_19_842 VDD VDD VSS VSS gf180mcu_fd_sc_mcu7t5v0__fillcap_64
XFILLER_21_517 VDD VDD VSS VSS gf180mcu_fd_sc_mcu7t5v0__fill_1
XTAP_TAPCELL_ROW_44_862 VDD VSS gf180mcu_fd_sc_mcu7t5v0__filltie
XFILLER_61_697 VDD VDD VSS VSS gf180mcu_fd_sc_mcu7t5v0__fill_2
X_1973_ _4061_/Q _3249_/A2 _4130_/D VDD VDD VSS VSS gf180mcu_fd_sc_mcu7t5v0__nor2_1
XFILLER_14_580 VDD VDD VSS VSS gf180mcu_fd_sc_mcu7t5v0__fillcap_8
X_3712_ _3712_/D _3738_/CLK _3712_/Q VDD VDD VSS VSS gf180mcu_fd_sc_mcu7t5v0__dffq_1
XTAP_TAPCELL_ROW_132_2003 VDD VSS gf180mcu_fd_sc_mcu7t5v0__filltie
X_3643_ _3643_/D _3755_/CLK _3643_/Q VDD VDD VSS VSS gf180mcu_fd_sc_mcu7t5v0__dffq_1
XTAP_TAPCELL_ROW_132_2014 VDD VSS gf180mcu_fd_sc_mcu7t5v0__filltie
XFILLER_115_622 VDD VDD VSS VSS gf180mcu_fd_sc_mcu7t5v0__fillcap_8
X_3574_ _3761_/Q _3817_/Q _3825_/Q _3833_/Q _4116_/Q place75/Z _3574_/Z VDD VDD VSS
+ VSS gf180mcu_fd_sc_mcu7t5v0__mux4_1
X_2456_ _4069_/Q _3703_/Q _2466_/S _3703_/D VDD VDD VSS VSS gf180mcu_fd_sc_mcu7t5v0__mux2_2
XFILLER_102_349 VDD VDD VSS VSS gf180mcu_fd_sc_mcu7t5v0__fillcap_16
XFILLER_96_583 VDD VDD VSS VSS gf180mcu_fd_sc_mcu7t5v0__fill_2
X_4126_ _4126_/D _2279_/I _4126_/CLK _4126_/Q VDD VDD VSS VSS gf180mcu_fd_sc_mcu7t5v0__dffrnq_1
X_2387_ _3672_/Q place81/Z _2395_/S _3672_/D VDD VDD VSS VSS gf180mcu_fd_sc_mcu7t5v0__mux2_2
XFILLER_68_241 VDD VDD VSS VSS gf180mcu_fd_sc_mcu7t5v0__fillcap_4
XFILLER_69_797 VDD VDD VSS VSS gf180mcu_fd_sc_mcu7t5v0__fill_1
XFILLER_84_734 VDD VDD VSS VSS gf180mcu_fd_sc_mcu7t5v0__fill_1
X_4057_ _4057_/D _4148_/RN _4057_/CLK _4057_/Q VDD VDD VSS VSS gf180mcu_fd_sc_mcu7t5v0__dffrnq_1
X_3008_ _3948_/Q _4036_/Q _3041_/S _3948_/D VDD VDD VSS VSS gf180mcu_fd_sc_mcu7t5v0__mux2_2
XFILLER_83_277 VDD VDD VSS VSS gf180mcu_fd_sc_mcu7t5v0__fill_2
XFILLER_24_311 VDD VDD VSS VSS gf180mcu_fd_sc_mcu7t5v0__fillcap_4
XFILLER_36_193 VDD VDD VSS VSS gf180mcu_fd_sc_mcu7t5v0__fillcap_4
XTAP_TAPCELL_ROW_65_1134 VDD VSS gf180mcu_fd_sc_mcu7t5v0__filltie
XTAP_TAPCELL_ROW_22_567 VDD VSS gf180mcu_fd_sc_mcu7t5v0__filltie
XFILLER_126_909 VDD VDD VSS VSS gf180mcu_fd_sc_mcu7t5v0__fillcap_16
XTAP_TAPCELL_ROW_117_1809 VDD VSS gf180mcu_fd_sc_mcu7t5v0__filltie
XTAP_TAPCELL_ROW_22_578 VDD VSS gf180mcu_fd_sc_mcu7t5v0__filltie
XFILLER_125_419 VDD VDD VSS VSS gf180mcu_fd_sc_mcu7t5v0__fill_1
XFILLER_4_727 VDD VDD VSS VSS gf180mcu_fd_sc_mcu7t5v0__fillcap_8
XTAP_TAPCELL_ROW_76_1274 VDD VSS gf180mcu_fd_sc_mcu7t5v0__filltie
XFILLER_120_102 VDD VDD VSS VSS gf180mcu_fd_sc_mcu7t5v0__fill_2
XFILLER_59_230 VDD VDD VSS VSS gf180mcu_fd_sc_mcu7t5v0__fill_1
XFILLER_120_168 VDD VDD VSS VSS gf180mcu_fd_sc_mcu7t5v0__fillcap_4
XTAP_TAPCELL_ROW_128_1949 VDD VSS gf180mcu_fd_sc_mcu7t5v0__filltie
XFILLER_19_138 VDD VDD VSS VSS gf180mcu_fd_sc_mcu7t5v0__fill_2
XFILLER_75_789 VDD VDD VSS VSS gf180mcu_fd_sc_mcu7t5v0__fill_1
XFILLER_74_244 VDD VDD VSS VSS gf180mcu_fd_sc_mcu7t5v0__fill_1
XFILLER_35_609 VDD VDD VSS VSS gf180mcu_fd_sc_mcu7t5v0__fillcap_4
XFILLER_16_867 VDD VDD VSS VSS gf180mcu_fd_sc_mcu7t5v0__fillcap_8
XFILLER_35_72 VDD VDD VSS VSS gf180mcu_fd_sc_mcu7t5v0__fillcap_64
XFILLER_43_686 VDD VDD VSS VSS gf180mcu_fd_sc_mcu7t5v0__fillcap_8
XTAP_TAPCELL_ROW_41_821 VDD VSS gf180mcu_fd_sc_mcu7t5v0__filltie
XFILLER_117_909 VDD VDD VSS VSS gf180mcu_fd_sc_mcu7t5v0__fill_1
XFILLER_11_594 VDD VDD VSS VSS gf180mcu_fd_sc_mcu7t5v0__fillcap_16
XFILLER_128_257 VDD VDD VSS VSS gf180mcu_fd_sc_mcu7t5v0__fillcap_8
XFILLER_97_314 VDD VDD VSS VSS gf180mcu_fd_sc_mcu7t5v0__fillcap_8
X_3290_ _4165_/Q _3907_/Q _3289_/Z _3290_/Z VDD VDD VSS VSS gf180mcu_fd_sc_mcu7t5v0__xor3_1
X_2241_ _2241_/I _2241_/ZN VDD VDD VSS VSS gf180mcu_fd_sc_mcu7t5v0__inv_1
XFILLER_111_146 VDD VDD VSS VSS gf180mcu_fd_sc_mcu7t5v0__fill_2
XTAP_TAPCELL_ROW_49_921 VDD VSS gf180mcu_fd_sc_mcu7t5v0__filltie
X_2172_ _3713_/Q _3721_/Q _3729_/Q _3737_/Q place79/Z place78/Z _2172_/Z VDD VDD VSS
+ VSS gf180mcu_fd_sc_mcu7t5v0__mux4_1
XFILLER_65_222 VDD VDD VSS VSS gf180mcu_fd_sc_mcu7t5v0__fill_1
XFILLER_19_683 VDD VDD VSS VSS gf180mcu_fd_sc_mcu7t5v0__fill_1
XFILLER_80_247 VDD VDD VSS VSS gf180mcu_fd_sc_mcu7t5v0__fillcap_32
XFILLER_22_815 VDD VDD VSS VSS gf180mcu_fd_sc_mcu7t5v0__fillcap_4
XFILLER_61_472 VDD VDD VSS VSS gf180mcu_fd_sc_mcu7t5v0__fill_2
X_1956_ _4080_/Q _3319_/B _3280_/A2 VDD VDD VSS VSS gf180mcu_fd_sc_mcu7t5v0__nand2_1
XTAP_TAPCELL_ROW_60_1064 VDD VSS gf180mcu_fd_sc_mcu7t5v0__filltie
X_1887_ _4138_/Q _1888_/B VDD VDD VSS VSS gf180mcu_fd_sc_mcu7t5v0__clkinv_1
X_3626_ _3626_/A1 _3626_/A2 _3607_/Z _3627_/S VDD VDD VSS VSS gf180mcu_fd_sc_mcu7t5v0__nor3_1
XPHY_EDGE_ROW_131_Right_131 VDD VSS gf180mcu_fd_sc_mcu7t5v0__endcap
XFILLER_115_430 VDD VDD VSS VSS gf180mcu_fd_sc_mcu7t5v0__fillcap_4
X_3557_ _3553_/Z _3554_/Z _3555_/Z _3556_/Z place74/Z _4119_/Q _3557_/Z VDD VDD VSS
+ VSS gf180mcu_fd_sc_mcu7t5v0__mux4_1
XTAP_TAPCELL_ROW_112_1739 VDD VSS gf180mcu_fd_sc_mcu7t5v0__filltie
XFILLER_88_325 VDD VDD VSS VSS gf180mcu_fd_sc_mcu7t5v0__fill_2
Xinput108 hold223/Z _3246_/A2 VDD VDD VSS VSS gf180mcu_fd_sc_mcu7t5v0__dlyb_1
XFILLER_88_347 VDD VDD VSS VSS gf180mcu_fd_sc_mcu7t5v0__fillcap_32
X_3488_ place91/Z _3488_/A2 _3493_/A1 VDD VDD VSS VSS gf180mcu_fd_sc_mcu7t5v0__nand2_1
XFILLER_130_477 VDD VDD VSS VSS gf180mcu_fd_sc_mcu7t5v0__fill_2
Xinput119 hold214/Z _3136_/I1 VDD VDD VSS VSS gf180mcu_fd_sc_mcu7t5v0__dlyb_1
XFILLER_56_27 VDD VDD VSS VSS gf180mcu_fd_sc_mcu7t5v0__fillcap_8
XFILLER_57_734 VDD VDD VSS VSS gf180mcu_fd_sc_mcu7t5v0__fillcap_8
X_4109_ _4109_/D _4157_/RN _4109_/CLK _4109_/Q VDD VDD VSS VSS gf180mcu_fd_sc_mcu7t5v0__dffsnq_1
XFILLER_84_597 VDD VDD VSS VSS gf180mcu_fd_sc_mcu7t5v0__fillcap_32
XFILLER_72_737 VDD VDD VSS VSS gf180mcu_fd_sc_mcu7t5v0__fillcap_64
XFILLER_44_439 VDD VDD VSS VSS gf180mcu_fd_sc_mcu7t5v0__fill_1
XFILLER_25_620 VDD VDD VSS VSS gf180mcu_fd_sc_mcu7t5v0__fillcap_8
XTAP_TAPCELL_ROW_27_637 VDD VSS gf180mcu_fd_sc_mcu7t5v0__filltie
XTAP_TAPCELL_ROW_123_1879 VDD VSS gf180mcu_fd_sc_mcu7t5v0__filltie
XFILLER_12_347 VDD VDD VSS VSS gf180mcu_fd_sc_mcu7t5v0__fill_1
XFILLER_40_667 VDD VDD VSS VSS gf180mcu_fd_sc_mcu7t5v0__fillcap_64
XTAP_TAPCELL_ROW_78_1303 VDD VSS gf180mcu_fd_sc_mcu7t5v0__filltie
XFILLER_125_238 VDD VDD VSS VSS gf180mcu_fd_sc_mcu7t5v0__fillcap_4
XFILLER_125_216 VDD VDD VSS VSS gf180mcu_fd_sc_mcu7t5v0__fill_1
XFILLER_119_780 VDD VDD VSS VSS gf180mcu_fd_sc_mcu7t5v0__fillcap_4
XFILLER_121_422 VDD VDD VSS VSS gf180mcu_fd_sc_mcu7t5v0__fillcap_8
XFILLER_79_347 VDD VDD VSS VSS gf180mcu_fd_sc_mcu7t5v0__fill_2
XFILLER_121_477 VDD VDD VSS VSS gf180mcu_fd_sc_mcu7t5v0__fillcap_8
XFILLER_94_317 VDD VDD VSS VSS gf180mcu_fd_sc_mcu7t5v0__fillcap_64
XFILLER_94_306 VDD VDD VSS VSS gf180mcu_fd_sc_mcu7t5v0__fillcap_8
XTAP_TAPCELL_ROW_7_373 VDD VSS gf180mcu_fd_sc_mcu7t5v0__filltie
XTAP_TAPCELL_ROW_89_1443 VDD VSS gf180mcu_fd_sc_mcu7t5v0__filltie
XFILLER_75_564 VDD VDD VSS VSS gf180mcu_fd_sc_mcu7t5v0__fill_1
XFILLER_47_266 VDD VDD VSS VSS gf180mcu_fd_sc_mcu7t5v0__fill_1
XFILLER_62_247 VDD VDD VSS VSS gf180mcu_fd_sc_mcu7t5v0__fillcap_16
XFILLER_90_567 VDD VDD VSS VSS gf180mcu_fd_sc_mcu7t5v0__fill_2
XFILLER_16_664 VDD VDD VSS VSS gf180mcu_fd_sc_mcu7t5v0__fill_1
XTAP_TAPCELL_ROW_54_990 VDD VSS gf180mcu_fd_sc_mcu7t5v0__filltie
X_1810_ _1935_/A1 _1935_/A2 _2013_/A4 _1935_/A4 _1942_/B VDD VDD VSS VSS gf180mcu_fd_sc_mcu7t5v0__nand4_2
XFILLER_31_656 VDD VDD VSS VSS gf180mcu_fd_sc_mcu7t5v0__fill_1
XFILLER_7_384 VDD VDD VSS VSS gf180mcu_fd_sc_mcu7t5v0__fillcap_16
X_3411_ _3413_/A1 _3413_/A2 _4097_/D VDD VDD VSS VSS gf180mcu_fd_sc_mcu7t5v0__xor2_1
XFILLER_125_772 VDD VDD VSS VSS gf180mcu_fd_sc_mcu7t5v0__fill_2
XFILLER_113_912 VDD VDD VSS VSS gf180mcu_fd_sc_mcu7t5v0__fillcap_16
XFILLER_98_601 VDD VDD VSS VSS gf180mcu_fd_sc_mcu7t5v0__fill_2
XFILLER_97_100 VDD VDD VSS VSS gf180mcu_fd_sc_mcu7t5v0__fill_1
X_3342_ _3349_/A1 _3906_/Q _3342_/B _3344_/A2 VDD VDD VSS VSS gf180mcu_fd_sc_mcu7t5v0__oai21_1
XFILLER_86_807 VDD VDD VSS VSS gf180mcu_fd_sc_mcu7t5v0__fillcap_32
XFILLER_30_2 VDD VDD VSS VSS gf180mcu_fd_sc_mcu7t5v0__fillcap_4
X_3273_ _4064_/Q _3256_/Z _3274_/A2 _3274_/B VDD VDD VSS VSS gf180mcu_fd_sc_mcu7t5v0__nor3_1
X_2224_ _3910_/Q place72/Z _2227_/A1 VDD VDD VSS VSS gf180mcu_fd_sc_mcu7t5v0__nand2_1
XFILLER_85_328 VDD VDD VSS VSS gf180mcu_fd_sc_mcu7t5v0__fill_1
X_2155_ _3903_/Q place72/Z place68/Z _3887_/Q _2155_/C _2156_/A3 VDD VDD VSS VSS gf180mcu_fd_sc_mcu7t5v0__aoi221_1
XFILLER_27_907 VDD VDD VSS VSS gf180mcu_fd_sc_mcu7t5v0__fill_2
XFILLER_38_244 VDD VDD VSS VSS gf180mcu_fd_sc_mcu7t5v0__fill_1
XFILLER_54_737 VDD VDD VSS VSS gf180mcu_fd_sc_mcu7t5v0__fillcap_16
XFILLER_66_597 VDD VDD VSS VSS gf180mcu_fd_sc_mcu7t5v0__fillcap_16
X_2086_ place71/Z _2097_/A2 _2097_/A3 _2085_/Z _2088_/A2 VDD VDD VSS VSS gf180mcu_fd_sc_mcu7t5v0__nand4_1
XFILLER_93_394 VDD VDD VSS VSS gf180mcu_fd_sc_mcu7t5v0__fillcap_8
XFILLER_81_556 VDD VDD VSS VSS gf180mcu_fd_sc_mcu7t5v0__fillcap_4
XFILLER_10_807 VDD VDD VSS VSS gf180mcu_fd_sc_mcu7t5v0__fillcap_16
XFILLER_22_667 VDD VDD VSS VSS gf180mcu_fd_sc_mcu7t5v0__fillcap_8
X_1939_ _1835_/B _1819_/Z _1820_/Z _1822_/Z _1940_/A2 VDD VDD VSS VSS gf180mcu_fd_sc_mcu7t5v0__nor4_2
X_3609_ _4161_/Q _3627_/I1 _3609_/S _4161_/D VDD VDD VSS VSS gf180mcu_fd_sc_mcu7t5v0__mux2_2
XFILLER_104_901 VDD VDD VSS VSS gf180mcu_fd_sc_mcu7t5v0__fill_1
XTAP_TAPCELL_ROW_73_1233 VDD VSS gf180mcu_fd_sc_mcu7t5v0__filltie
XFILLER_115_282 VDD VDD VSS VSS gf180mcu_fd_sc_mcu7t5v0__fillcap_32
XFILLER_103_422 VDD VDD VSS VSS gf180mcu_fd_sc_mcu7t5v0__fillcap_64
XFILLER_103_411 VDD VDD VSS VSS gf180mcu_fd_sc_mcu7t5v0__fillcap_8
XFILLER_131_753 VDD VDD VSS VSS gf180mcu_fd_sc_mcu7t5v0__fill_1
XFILLER_130_230 VDD VDD VSS VSS gf180mcu_fd_sc_mcu7t5v0__fillcap_8
XFILLER_76_317 VDD VDD VSS VSS gf180mcu_fd_sc_mcu7t5v0__fillcap_16
XTAP_TAPCELL_ROW_4_332 VDD VSS gf180mcu_fd_sc_mcu7t5v0__filltie
XTAP_TAPCELL_ROW_4_343 VDD VSS gf180mcu_fd_sc_mcu7t5v0__filltie
XFILLER_29_244 VDD VDD VSS VSS gf180mcu_fd_sc_mcu7t5v0__fill_2
XTAP_TAPCELL_ROW_125_1908 VDD VSS gf180mcu_fd_sc_mcu7t5v0__filltie
XFILLER_18_929 VDD VDD VSS VSS gf180mcu_fd_sc_mcu7t5v0__fillcap_4
XFILLER_45_748 VDD VDD VSS VSS gf180mcu_fd_sc_mcu7t5v0__fillcap_4
XFILLER_44_269 VDD VDD VSS VSS gf180mcu_fd_sc_mcu7t5v0__fill_2
XTAP_TAPCELL_ROW_84_1384 VDD VSS gf180mcu_fd_sc_mcu7t5v0__filltie
XTAP_TAPCELL_ROW_84_1373 VDD VSS gf180mcu_fd_sc_mcu7t5v0__filltie
XPHY_EDGE_ROW_11_Right_11 VDD VSS gf180mcu_fd_sc_mcu7t5v0__endcap
XFILLER_12_100 VDD VDD VSS VSS gf180mcu_fd_sc_mcu7t5v0__fillcap_4
XFILLER_41_932 VDD VDD VSS VSS gf180mcu_fd_sc_mcu7t5v0__fill_2
XFILLER_12_177 VDD VDD VSS VSS gf180mcu_fd_sc_mcu7t5v0__fill_1
XFILLER_107_750 VDD VDD VSS VSS gf180mcu_fd_sc_mcu7t5v0__fillcap_4
XFILLER_107_772 VDD VDD VSS VSS gf180mcu_fd_sc_mcu7t5v0__fillcap_16
XFILLER_122_731 VDD VDD VSS VSS gf180mcu_fd_sc_mcu7t5v0__fillcap_4
XFILLER_106_271 VDD VDD VSS VSS gf180mcu_fd_sc_mcu7t5v0__fill_2
XFILLER_4_387 VDD VDD VSS VSS gf180mcu_fd_sc_mcu7t5v0__fillcap_8
XPHY_EDGE_ROW_20_Right_20 VDD VSS gf180mcu_fd_sc_mcu7t5v0__endcap
XFILLER_95_626 VDD VDD VSS VSS gf180mcu_fd_sc_mcu7t5v0__fillcap_4
XFILLER_48_520 VDD VDD VSS VSS gf180mcu_fd_sc_mcu7t5v0__fillcap_4
XFILLER_75_372 VDD VDD VSS VSS gf180mcu_fd_sc_mcu7t5v0__fill_2
XFILLER_36_737 VDD VDD VSS VSS gf180mcu_fd_sc_mcu7t5v0__fillcap_16
XFILLER_48_597 VDD VDD VSS VSS gf180mcu_fd_sc_mcu7t5v0__fillcap_64
XFILLER_57_92 VDD VDD VSS VSS gf180mcu_fd_sc_mcu7t5v0__fill_2
X_3960_ _3960_/D _2279_/I _3968_/CLK _3960_/Q VDD VDD VSS VSS gf180mcu_fd_sc_mcu7t5v0__dffrnq_1
XFILLER_51_718 VDD VDD VSS VSS gf180mcu_fd_sc_mcu7t5v0__fillcap_4
XFILLER_73_80 VDD VDD VSS VSS gf180mcu_fd_sc_mcu7t5v0__fill_2
X_3891_ _3891_/D _4157_/RN _4127_/CLK _3891_/Q VDD VDD VSS VSS gf180mcu_fd_sc_mcu7t5v0__dffrnq_1
XFILLER_31_486 VDD VDD VSS VSS gf180mcu_fd_sc_mcu7t5v0__fillcap_4
X_2842_ place87/Z _3872_/Q _2850_/S _3872_/D VDD VDD VSS VSS gf180mcu_fd_sc_mcu7t5v0__mux2_2
XFILLER_99_932 VDD VDD VSS VSS gf180mcu_fd_sc_mcu7t5v0__fill_2
XFILLER_112_241 VDD VDD VSS VSS gf180mcu_fd_sc_mcu7t5v0__fillcap_4
X_3325_ _4158_/Q _3338_/A1 VDD VDD VSS VSS gf180mcu_fd_sc_mcu7t5v0__clkinv_1
X_3256_ _4080_/Q _3607_/A2 _3256_/A3 _3256_/Z VDD VDD VSS VSS gf180mcu_fd_sc_mcu7t5v0__or3_2
XFILLER_58_317 VDD VDD VSS VSS gf180mcu_fd_sc_mcu7t5v0__fillcap_4
XFILLER_86_659 VDD VDD VSS VSS gf180mcu_fd_sc_mcu7t5v0__fillcap_4
X_2207_ _3891_/Q place68/Z _2216_/B1 _4065_/Q place63/Z _3939_/Q _2208_/A3 VDD VDD
+ VSS VSS gf180mcu_fd_sc_mcu7t5v0__aoi222_1
XFILLER_85_136 VDD VDD VSS VSS gf180mcu_fd_sc_mcu7t5v0__fillcap_4
XTAP_TAPCELL_ROW_1_302 VDD VSS gf180mcu_fd_sc_mcu7t5v0__filltie
XFILLER_81_320 VDD VDD VSS VSS gf180mcu_fd_sc_mcu7t5v0__fillcap_16
X_2138_ _4111_/Q _3934_/Q _2152_/S _2138_/Z VDD VDD VSS VSS gf180mcu_fd_sc_mcu7t5v0__mux2_2
X_2069_ _4142_/Q _2073_/A2 _2069_/Z VDD VDD VSS VSS gf180mcu_fd_sc_mcu7t5v0__xor2_1
XFILLER_26_247 VDD VDD VSS VSS gf180mcu_fd_sc_mcu7t5v0__fillcap_64
XTAP_TAPCELL_ROW_37_765 VDD VSS gf180mcu_fd_sc_mcu7t5v0__filltie
XFILLER_54_589 VDD VDD VSS VSS gf180mcu_fd_sc_mcu7t5v0__fillcap_4
XFILLER_23_932 VDD VDD VSS VSS gf180mcu_fd_sc_mcu7t5v0__fill_2
XTAP_TAPCELL_ROW_120_1849 VDD VSS gf180mcu_fd_sc_mcu7t5v0__filltie
XFILLER_10_637 VDD VDD VSS VSS gf180mcu_fd_sc_mcu7t5v0__fill_2
XTAP_TAPCELL_ROW_9_402 VDD VSS gf180mcu_fd_sc_mcu7t5v0__filltie
XFILLER_2_803 VDD VDD VSS VSS gf180mcu_fd_sc_mcu7t5v0__fill_2
XFILLER_116_591 VDD VDD VSS VSS gf180mcu_fd_sc_mcu7t5v0__fillcap_4
XTAP_TAPCELL_ROW_131_1989 VDD VSS gf180mcu_fd_sc_mcu7t5v0__filltie
XFILLER_89_486 VDD VDD VSS VSS gf180mcu_fd_sc_mcu7t5v0__fillcap_4
XTAP_TAPCELL_ROW_86_1402 VDD VSS gf180mcu_fd_sc_mcu7t5v0__filltie
XFILLER_57_372 VDD VDD VSS VSS gf180mcu_fd_sc_mcu7t5v0__fill_1
XFILLER_91_139 VDD VDD VSS VSS gf180mcu_fd_sc_mcu7t5v0__fill_1
XFILLER_18_737 VDD VDD VSS VSS gf180mcu_fd_sc_mcu7t5v0__fill_2
XFILLER_27_84 VDD VDD VSS VSS gf180mcu_fd_sc_mcu7t5v0__fill_2
XFILLER_60_559 VDD VDD VSS VSS gf180mcu_fd_sc_mcu7t5v0__fillcap_4
XFILLER_13_486 VDD VDD VSS VSS gf180mcu_fd_sc_mcu7t5v0__fillcap_4
XFILLER_43_72 VDD VDD VSS VSS gf180mcu_fd_sc_mcu7t5v0__fillcap_64
XFILLER_127_834 VDD VDD VSS VSS gf180mcu_fd_sc_mcu7t5v0__fillcap_4
XTAP_TAPCELL_ROW_97_1542 VDD VSS gf180mcu_fd_sc_mcu7t5v0__filltie
XTAP_TAPCELL_ROW_97_1553 VDD VSS gf180mcu_fd_sc_mcu7t5v0__filltie
XFILLER_4_66 VDD VDD VSS VSS gf180mcu_fd_sc_mcu7t5v0__fillcap_4
XFILLER_122_594 VDD VDD VSS VSS gf180mcu_fd_sc_mcu7t5v0__fill_1
X_3110_ _3996_/Q _3110_/I1 _3160_/S _3996_/D VDD VDD VSS VSS gf180mcu_fd_sc_mcu7t5v0__mux2_2
X_4090_ _4090_/D _2279_/I _4092_/CLK _4090_/Q VDD VDD VSS VSS gf180mcu_fd_sc_mcu7t5v0__dffrnq_1
X_3041_ _3964_/Q _4052_/Q _3041_/S _3964_/D VDD VDD VSS VSS gf180mcu_fd_sc_mcu7t5v0__mux2_2
XFILLER_91_640 VDD VDD VSS VSS gf180mcu_fd_sc_mcu7t5v0__fillcap_4
XFILLER_51_504 VDD VDD VSS VSS gf180mcu_fd_sc_mcu7t5v0__fill_2
XTAP_TAPCELL_ROW_106_1660 VDD VSS gf180mcu_fd_sc_mcu7t5v0__filltie
XTAP_TAPCELL_ROW_34_724 VDD VSS gf180mcu_fd_sc_mcu7t5v0__filltie
X_3943_ _3943_/D _4157_/RN _3976_/CLK _3943_/Q VDD VDD VSS VSS gf180mcu_fd_sc_mcu7t5v0__dffrnq_1
X_3874_ _3874_/D _4057_/CLK _3874_/Q VDD VDD VSS VSS gf180mcu_fd_sc_mcu7t5v0__dffq_1
Xclkbuf_3_2__f_clk clkbuf_0_clk/Z clkload1/I VDD VDD VSS VSS gf180mcu_fd_sc_mcu7t5v0__clkbuf_16
XTAP_TAPCELL_ROW_14_470 VDD VSS gf180mcu_fd_sc_mcu7t5v0__filltie
X_2825_ place87/Z _3864_/Q _2833_/S _3864_/D VDD VDD VSS VSS gf180mcu_fd_sc_mcu7t5v0__mux2_2
X_2756_ _3832_/Q place87/Z _2764_/S _3832_/D VDD VDD VSS VSS gf180mcu_fd_sc_mcu7t5v0__mux2_2
X_2687_ place86/Z _3801_/Q _2693_/S _3801_/D VDD VDD VSS VSS gf180mcu_fd_sc_mcu7t5v0__mux2_2
XTAP_TAPCELL_ROW_57_1025 VDD VSS gf180mcu_fd_sc_mcu7t5v0__filltie
XFILLER_58_103 VDD VDD VSS VSS gf180mcu_fd_sc_mcu7t5v0__fill_2
XFILLER_100_266 VDD VDD VSS VSS gf180mcu_fd_sc_mcu7t5v0__fill_2
XFILLER_86_478 VDD VDD VSS VSS gf180mcu_fd_sc_mcu7t5v0__fillcap_4
X_3239_ _4058_/Q _3988_/Q _4129_/D _4058_/D VDD VDD VSS VSS gf180mcu_fd_sc_mcu7t5v0__mux2_2
XFILLER_58_169 VDD VDD VSS VSS gf180mcu_fd_sc_mcu7t5v0__fillcap_4
XFILLER_73_139 VDD VDD VSS VSS gf180mcu_fd_sc_mcu7t5v0__fill_1
XFILLER_27_523 VDD VDD VSS VSS gf180mcu_fd_sc_mcu7t5v0__fillcap_4
XFILLER_55_832 VDD VDD VSS VSS gf180mcu_fd_sc_mcu7t5v0__fillcap_8
XFILLER_64_27 VDD VDD VSS VSS gf180mcu_fd_sc_mcu7t5v0__fillcap_8
XFILLER_82_662 VDD VDD VSS VSS gf180mcu_fd_sc_mcu7t5v0__fill_2
XFILLER_15_718 VDD VDD VSS VSS gf180mcu_fd_sc_mcu7t5v0__fillcap_8
XFILLER_27_578 VDD VDD VSS VSS gf180mcu_fd_sc_mcu7t5v0__fillcap_8
XFILLER_64_49 VDD VDD VSS VSS gf180mcu_fd_sc_mcu7t5v0__fill_2
XTAP_TAPCELL_ROW_68_1165 VDD VSS gf180mcu_fd_sc_mcu7t5v0__filltie
XTAP_TAPCELL_ROW_68_1176 VDD VSS gf180mcu_fd_sc_mcu7t5v0__filltie
XTAP_TAPCELL_ROW_81_1343 VDD VSS gf180mcu_fd_sc_mcu7t5v0__filltie
XFILLER_120_77 VDD VDD VSS VSS gf180mcu_fd_sc_mcu7t5v0__fill_2
XFILLER_7_906 VDD VDD VSS VSS gf180mcu_fd_sc_mcu7t5v0__fillcap_4
XFILLER_7_928 VDD VDD VSS VSS gf180mcu_fd_sc_mcu7t5v0__fillcap_4
XFILLER_129_64 VDD VDD VSS VSS gf180mcu_fd_sc_mcu7t5v0__fillcap_4
XFILLER_108_311 VDD VDD VSS VSS gf180mcu_fd_sc_mcu7t5v0__fillcap_4
XFILLER_124_804 VDD VDD VSS VSS gf180mcu_fd_sc_mcu7t5v0__fill_1
XFILLER_123_358 VDD VDD VSS VSS gf180mcu_fd_sc_mcu7t5v0__fillcap_16
XFILLER_96_209 VDD VDD VSS VSS gf180mcu_fd_sc_mcu7t5v0__fillcap_8
XFILLER_132_892 VDD VDD VSS VSS gf180mcu_fd_sc_mcu7t5v0__fill_1
XTAP_TAPCELL_ROW_92_1483 VDD VSS gf180mcu_fd_sc_mcu7t5v0__filltie
XFILLER_78_924 VDD VDD VSS VSS gf180mcu_fd_sc_mcu7t5v0__fillcap_8
XFILLER_49_136 VDD VDD VSS VSS gf180mcu_fd_sc_mcu7t5v0__fillcap_4
XFILLER_93_927 VDD VDD VSS VSS gf180mcu_fd_sc_mcu7t5v0__fillcap_4
XFILLER_92_437 VDD VDD VSS VSS gf180mcu_fd_sc_mcu7t5v0__fillcap_4
XFILLER_72_172 VDD VDD VSS VSS gf180mcu_fd_sc_mcu7t5v0__fill_2
XFILLER_54_93 VDD VDD VSS VSS gf180mcu_fd_sc_mcu7t5v0__fillcap_8
Xclkload24 _4045_/CLK clkload24/ZN VDD VDD VSS VSS gf180mcu_fd_sc_mcu7t5v0__clkinv_2
Xclkload35 _4159_/CLK clkload35/Z VDD VDD VSS VSS gf180mcu_fd_sc_mcu7t5v0__clkbuf_4
Xclkload13 _3864_/CLK clkload13/Z VDD VDD VSS VSS gf180mcu_fd_sc_mcu7t5v0__clkbuf_2
X_3590_ _3875_/Q _3883_/Q _3771_/Q _3779_/Q place76/Z place75/Z _3590_/Z VDD VDD VSS
+ VSS gf180mcu_fd_sc_mcu7t5v0__mux4_1
Xclkload46 _3976_/CLK clkload46/Z VDD VDD VSS VSS gf180mcu_fd_sc_mcu7t5v0__clkbuf_2
XFILLER_114_303 VDD VDD VSS VSS gf180mcu_fd_sc_mcu7t5v0__fillcap_8
XFILLER_126_185 VDD VDD VSS VSS gf180mcu_fd_sc_mcu7t5v0__fillcap_4
XFILLER_126_163 VDD VDD VSS VSS gf180mcu_fd_sc_mcu7t5v0__fillcap_8
XFILLER_114_325 VDD VDD VSS VSS gf180mcu_fd_sc_mcu7t5v0__fillcap_4
XFILLER_130_818 VDD VDD VSS VSS gf180mcu_fd_sc_mcu7t5v0__fill_2
XFILLER_130_807 VDD VDD VSS VSS gf180mcu_fd_sc_mcu7t5v0__fill_2
XFILLER_114_347 VDD VDD VSS VSS gf180mcu_fd_sc_mcu7t5v0__fillcap_8
XFILLER_87_209 VDD VDD VSS VSS gf180mcu_fd_sc_mcu7t5v0__fill_1
XFILLER_130_829 VDD VDD VSS VSS gf180mcu_fd_sc_mcu7t5v0__fill_2
X_4142_ _4142_/D _4148_/RN _4147_/CLK _4142_/Q VDD VDD VSS VSS gf180mcu_fd_sc_mcu7t5v0__dffrnq_1
XFILLER_95_220 VDD VDD VSS VSS gf180mcu_fd_sc_mcu7t5v0__fill_2
X_4073_ _4073_/D input92/Z _4166_/CLK _4073_/Q VDD VDD VSS VSS gf180mcu_fd_sc_mcu7t5v0__dffrnq_1
XFILLER_110_597 VDD VDD VSS VSS gf180mcu_fd_sc_mcu7t5v0__fillcap_64
XTAP_TAPCELL_ROW_47_893 VDD VSS gf180mcu_fd_sc_mcu7t5v0__filltie
XFILLER_91_492 VDD VDD VSS VSS gf180mcu_fd_sc_mcu7t5v0__fillcap_32
XFILLER_24_559 VDD VDD VSS VSS gf180mcu_fd_sc_mcu7t5v0__fillcap_4
X_3926_ _3926_/D _2279_/I _4098_/CLK _3926_/Q VDD VDD VSS VSS gf180mcu_fd_sc_mcu7t5v0__dffrnq_1
XFILLER_11_209 VDD VDD VSS VSS gf180mcu_fd_sc_mcu7t5v0__fill_1
X_3857_ _3857_/D _3865_/CLK _3857_/Q VDD VDD VSS VSS gf180mcu_fd_sc_mcu7t5v0__dffq_1
Xclkload7 clkload7/I clkload7/ZN VDD VDD VSS VSS gf180mcu_fd_sc_mcu7t5v0__clkinv_1
X_2808_ place87/Z _3856_/Q _2816_/S _3856_/D VDD VDD VSS VSS gf180mcu_fd_sc_mcu7t5v0__mux2_2
X_3788_ _3788_/D clkload8/I _3788_/Q VDD VDD VSS VSS gf180mcu_fd_sc_mcu7t5v0__dffq_1
XFILLER_118_664 VDD VDD VSS VSS gf180mcu_fd_sc_mcu7t5v0__fill_1
XFILLER_106_804 VDD VDD VSS VSS gf180mcu_fd_sc_mcu7t5v0__fill_1
XFILLER_4_909 VDD VDD VSS VSS gf180mcu_fd_sc_mcu7t5v0__fillcap_16
XFILLER_3_408 VDD VDD VSS VSS gf180mcu_fd_sc_mcu7t5v0__fillcap_8
XFILLER_78_209 VDD VDD VSS VSS gf180mcu_fd_sc_mcu7t5v0__fillcap_8
XFILLER_120_339 VDD VDD VSS VSS gf180mcu_fd_sc_mcu7t5v0__fill_1
XFILLER_86_275 VDD VDD VSS VSS gf180mcu_fd_sc_mcu7t5v0__fill_2
XFILLER_47_629 VDD VDD VSS VSS gf180mcu_fd_sc_mcu7t5v0__fill_1
XFILLER_75_59 VDD VDD VSS VSS gf180mcu_fd_sc_mcu7t5v0__fillcap_8
XFILLER_46_117 VDD VDD VSS VSS gf180mcu_fd_sc_mcu7t5v0__fill_1
XFILLER_15_515 VDD VDD VSS VSS gf180mcu_fd_sc_mcu7t5v0__fill_2
XFILLER_54_172 VDD VDD VSS VSS gf180mcu_fd_sc_mcu7t5v0__fill_2
XFILLER_91_69 VDD VDD VSS VSS gf180mcu_fd_sc_mcu7t5v0__fill_1
XFILLER_30_518 VDD VDD VSS VSS gf180mcu_fd_sc_mcu7t5v0__fillcap_4
XFILLER_24_63 VDD VDD VSS VSS gf180mcu_fd_sc_mcu7t5v0__fillcap_32
XTAP_TAPCELL_ROW_94_1512 VDD VSS gf180mcu_fd_sc_mcu7t5v0__filltie
XFILLER_108_174 VDD VDD VSS VSS gf180mcu_fd_sc_mcu7t5v0__fill_1
XFILLER_124_667 VDD VDD VSS VSS gf180mcu_fd_sc_mcu7t5v0__fillcap_64
XFILLER_112_807 VDD VDD VSS VSS gf180mcu_fd_sc_mcu7t5v0__fillcap_64
XFILLER_69_209 VDD VDD VSS VSS gf180mcu_fd_sc_mcu7t5v0__fill_1
XFILLER_93_702 VDD VDD VSS VSS gf180mcu_fd_sc_mcu7t5v0__fillcap_64
XFILLER_37_139 VDD VDD VSS VSS gf180mcu_fd_sc_mcu7t5v0__fill_1
XFILLER_80_407 VDD VDD VSS VSS gf180mcu_fd_sc_mcu7t5v0__fill_1
XFILLER_45_150 VDD VDD VSS VSS gf180mcu_fd_sc_mcu7t5v0__fillcap_4
XFILLER_73_492 VDD VDD VSS VSS gf180mcu_fd_sc_mcu7t5v0__fillcap_64
XFILLER_61_632 VDD VDD VSS VSS gf180mcu_fd_sc_mcu7t5v0__fill_2
XTAP_TAPCELL_ROW_103_1630 VDD VSS gf180mcu_fd_sc_mcu7t5v0__filltie
XFILLER_21_507 VDD VDD VSS VSS gf180mcu_fd_sc_mcu7t5v0__fillcap_8
XTAP_TAPCELL_ROW_44_852 VDD VSS gf180mcu_fd_sc_mcu7t5v0__filltie
XTAP_TAPCELL_ROW_44_863 VDD VSS gf180mcu_fd_sc_mcu7t5v0__filltie
XFILLER_60_142 VDD VDD VSS VSS gf180mcu_fd_sc_mcu7t5v0__fill_2
X_1972_ _1972_/A1 _1972_/A2 _3249_/A2 VDD VDD VSS VSS gf180mcu_fd_sc_mcu7t5v0__nand2_1
XFILLER_14_592 VDD VDD VSS VSS gf180mcu_fd_sc_mcu7t5v0__fill_2
XPHY_EDGE_ROW_112_Right_112 VDD VSS gf180mcu_fd_sc_mcu7t5v0__endcap
X_3711_ _3711_/D _3729_/CLK _3711_/Q VDD VDD VSS VSS gf180mcu_fd_sc_mcu7t5v0__dffq_1
XTAP_TAPCELL_ROW_132_2004 VDD VSS gf180mcu_fd_sc_mcu7t5v0__filltie
X_3642_ _3642_/D _4094_/CLK _3642_/Q VDD VDD VSS VSS gf180mcu_fd_sc_mcu7t5v0__dffq_1
XTAP_TAPCELL_ROW_132_2015 VDD VSS gf180mcu_fd_sc_mcu7t5v0__filltie
XPHY_EDGE_ROW_49_Right_49 VDD VSS gf180mcu_fd_sc_mcu7t5v0__endcap
X_2524_ place82/Z _3733_/Q _2538_/S _3733_/D VDD VDD VSS VSS gf180mcu_fd_sc_mcu7t5v0__mux2_2
XTAP_TAPCELL_ROW_114_1770 VDD VSS gf180mcu_fd_sc_mcu7t5v0__filltie
XFILLER_114_177 VDD VDD VSS VSS gf180mcu_fd_sc_mcu7t5v0__fillcap_32
XFILLER_102_317 VDD VDD VSS VSS gf180mcu_fd_sc_mcu7t5v0__fillcap_32
XFILLER_69_710 VDD VDD VSS VSS gf180mcu_fd_sc_mcu7t5v0__fillcap_4
XFILLER_130_648 VDD VDD VSS VSS gf180mcu_fd_sc_mcu7t5v0__fillcap_16
X_4125_ _4125_/D _2279_/I _4125_/CLK _4125_/Q VDD VDD VSS VSS gf180mcu_fd_sc_mcu7t5v0__dffrnq_1
XFILLER_29_629 VDD VDD VSS VSS gf180mcu_fd_sc_mcu7t5v0__fill_1
XFILLER_83_212 VDD VDD VSS VSS gf180mcu_fd_sc_mcu7t5v0__fillcap_16
XFILLER_28_139 VDD VDD VSS VSS gf180mcu_fd_sc_mcu7t5v0__fillcap_4
XFILLER_56_448 VDD VDD VSS VSS gf180mcu_fd_sc_mcu7t5v0__fillcap_4
XFILLER_84_768 VDD VDD VSS VSS gf180mcu_fd_sc_mcu7t5v0__fill_2
XPHY_EDGE_ROW_58_Right_58 VDD VSS gf180mcu_fd_sc_mcu7t5v0__endcap
X_4056_ _4056_/D _4148_/RN _4115_/CLK _4056_/Q VDD VDD VSS VSS gf180mcu_fd_sc_mcu7t5v0__dffrnq_1
XTAP_TAPCELL_ROW_65_1135 VDD VSS gf180mcu_fd_sc_mcu7t5v0__filltie
XFILLER_101_46 VDD VDD VSS VSS gf180mcu_fd_sc_mcu7t5v0__fillcap_16
XFILLER_51_142 VDD VDD VSS VSS gf180mcu_fd_sc_mcu7t5v0__fillcap_8
XFILLER_51_186 VDD VDD VSS VSS gf180mcu_fd_sc_mcu7t5v0__fillcap_16
X_3909_ _3909_/D _4157_/RN _4092_/CLK _3909_/Q VDD VDD VSS VSS gf180mcu_fd_sc_mcu7t5v0__dffrnq_1
XTAP_TAPCELL_ROW_22_568 VDD VSS gf180mcu_fd_sc_mcu7t5v0__filltie
XPHY_EDGE_ROW_67_Right_67 VDD VSS gf180mcu_fd_sc_mcu7t5v0__endcap
XFILLER_3_227 VDD VDD VSS VSS gf180mcu_fd_sc_mcu7t5v0__fillcap_16
XTAP_TAPCELL_ROW_76_1275 VDD VSS gf180mcu_fd_sc_mcu7t5v0__filltie
XFILLER_102_873 VDD VDD VSS VSS gf180mcu_fd_sc_mcu7t5v0__fill_2
XFILLER_87_562 VDD VDD VSS VSS gf180mcu_fd_sc_mcu7t5v0__fillcap_64
XFILLER_48_927 VDD VDD VSS VSS gf180mcu_fd_sc_mcu7t5v0__fillcap_4
XPHY_EDGE_ROW_76_Right_76 VDD VSS gf180mcu_fd_sc_mcu7t5v0__endcap
XFILLER_47_437 VDD VDD VSS VSS gf180mcu_fd_sc_mcu7t5v0__fillcap_16
XFILLER_43_632 VDD VDD VSS VSS gf180mcu_fd_sc_mcu7t5v0__fillcap_8
XFILLER_55_492 VDD VDD VSS VSS gf180mcu_fd_sc_mcu7t5v0__fillcap_4
XFILLER_70_451 VDD VDD VSS VSS gf180mcu_fd_sc_mcu7t5v0__fillcap_4
XTAP_TAPCELL_ROW_41_822 VDD VSS gf180mcu_fd_sc_mcu7t5v0__filltie
XFILLER_43_698 VDD VDD VSS VSS gf180mcu_fd_sc_mcu7t5v0__fill_2
XPHY_EDGE_ROW_85_Right_85 VDD VSS gf180mcu_fd_sc_mcu7t5v0__endcap
XFILLER_11_562 VDD VDD VSS VSS gf180mcu_fd_sc_mcu7t5v0__fillcap_32
XFILLER_51_72 VDD VDD VSS VSS gf180mcu_fd_sc_mcu7t5v0__fillcap_64
XFILLER_125_932 VDD VDD VSS VSS gf180mcu_fd_sc_mcu7t5v0__fill_2
XFILLER_3_772 VDD VDD VSS VSS gf180mcu_fd_sc_mcu7t5v0__fillcap_32
X_2240_ _3899_/Q place68/Z place63/Z _3947_/Q _3915_/Q place72/Z _2241_/I VDD VDD
+ VSS VSS gf180mcu_fd_sc_mcu7t5v0__aoi222_1
XFILLER_111_136 VDD VDD VSS VSS gf180mcu_fd_sc_mcu7t5v0__fillcap_4
XFILLER_97_348 VDD VDD VSS VSS gf180mcu_fd_sc_mcu7t5v0__fill_2
XPHY_EDGE_ROW_94_Right_94 VDD VSS gf180mcu_fd_sc_mcu7t5v0__endcap
XTAP_TAPCELL_ROW_49_922 VDD VSS gf180mcu_fd_sc_mcu7t5v0__filltie
X_2171_ _3633_/Q _3689_/Q _3697_/Q _3705_/Q place79/Z place78/Z _2171_/Z VDD VDD VSS
+ VSS gf180mcu_fd_sc_mcu7t5v0__mux4_1
XFILLER_65_212 VDD VDD VSS VSS gf180mcu_fd_sc_mcu7t5v0__fillcap_8
XFILLER_80_237 VDD VDD VSS VSS gf180mcu_fd_sc_mcu7t5v0__fillcap_8
XFILLER_18_172 VDD VDD VSS VSS gf180mcu_fd_sc_mcu7t5v0__fill_2
Xplace90 _4021_/Q place90/Z VDD VDD VSS VSS gf180mcu_fd_sc_mcu7t5v0__buf_8
XFILLER_33_142 VDD VDD VSS VSS gf180mcu_fd_sc_mcu7t5v0__fillcap_64
X_1955_ _4078_/Q _4079_/Q _3319_/B VDD VDD VSS VSS gf180mcu_fd_sc_mcu7t5v0__nor2_2
XFILLER_30_893 VDD VDD VSS VSS gf180mcu_fd_sc_mcu7t5v0__fillcap_4
XTAP_TAPCELL_ROW_60_1065 VDD VSS gf180mcu_fd_sc_mcu7t5v0__filltie
X_1886_ _3891_/Q _2887_/A1 VDD VDD VSS VSS gf180mcu_fd_sc_mcu7t5v0__clkinv_1
X_3556_ _3782_/Q _3790_/Q _3798_/Q _3806_/Q place76/Z place75/Z _3556_/Z VDD VDD VSS
+ VSS gf180mcu_fd_sc_mcu7t5v0__mux4_1
XFILLER_115_486 VDD VDD VSS VSS gf180mcu_fd_sc_mcu7t5v0__fillcap_4
XFILLER_89_838 VDD VDD VSS VSS gf180mcu_fd_sc_mcu7t5v0__fill_2
X_2507_ _3725_/Q place82/Z _2521_/S _3725_/D VDD VDD VSS VSS gf180mcu_fd_sc_mcu7t5v0__mux2_2
X_3487_ _4155_/Q _3487_/A2 _3488_/A2 VDD VDD VSS VSS gf180mcu_fd_sc_mcu7t5v0__xnor2_1
Xinput109 hold201/Z _3096_/I1 VDD VDD VSS VSS gf180mcu_fd_sc_mcu7t5v0__dlyb_1
XFILLER_102_169 VDD VDD VSS VSS gf180mcu_fd_sc_mcu7t5v0__fillcap_4
XFILLER_57_702 VDD VDD VSS VSS gf180mcu_fd_sc_mcu7t5v0__fillcap_32
X_2438_ _3695_/Q _4069_/Q _2448_/S _3695_/D VDD VDD VSS VSS gf180mcu_fd_sc_mcu7t5v0__mux2_2
XFILLER_69_562 VDD VDD VSS VSS gf180mcu_fd_sc_mcu7t5v0__fillcap_4
XFILLER_84_521 VDD VDD VSS VSS gf180mcu_fd_sc_mcu7t5v0__fillcap_4
X_2369_ _3664_/Q place81/Z _2377_/S _3664_/D VDD VDD VSS VSS gf180mcu_fd_sc_mcu7t5v0__mux2_2
XFILLER_84_532 VDD VDD VSS VSS gf180mcu_fd_sc_mcu7t5v0__fill_2
X_4108_ _4108_/D _4157_/RN _4108_/CLK _4108_/Q VDD VDD VSS VSS gf180mcu_fd_sc_mcu7t5v0__dffrnq_1
X_4039_ _4039_/D _4148_/RN _4147_/CLK _4039_/Q VDD VDD VSS VSS gf180mcu_fd_sc_mcu7t5v0__dffrnq_1
XFILLER_25_632 VDD VDD VSS VSS gf180mcu_fd_sc_mcu7t5v0__fillcap_64
XTAP_TAPCELL_ROW_27_638 VDD VSS gf180mcu_fd_sc_mcu7t5v0__filltie
XFILLER_37_492 VDD VDD VSS VSS gf180mcu_fd_sc_mcu7t5v0__fillcap_32
XFILLER_72_27 VDD VDD VSS VSS gf180mcu_fd_sc_mcu7t5v0__fillcap_8
XFILLER_8_308 VDD VDD VSS VSS gf180mcu_fd_sc_mcu7t5v0__fillcap_4
XTAP_TAPCELL_ROW_78_1304 VDD VSS gf180mcu_fd_sc_mcu7t5v0__filltie
XFILLER_107_932 VDD VDD VSS VSS gf180mcu_fd_sc_mcu7t5v0__fill_2
XFILLER_121_434 VDD VDD VSS VSS gf180mcu_fd_sc_mcu7t5v0__fill_1
XTAP_TAPCELL_ROW_7_374 VDD VSS gf180mcu_fd_sc_mcu7t5v0__filltie
XFILLER_121_489 VDD VDD VSS VSS gf180mcu_fd_sc_mcu7t5v0__fill_1
XFILLER_47_212 VDD VDD VSS VSS gf180mcu_fd_sc_mcu7t5v0__fillcap_4
XTAP_TAPCELL_ROW_89_1444 VDD VSS gf180mcu_fd_sc_mcu7t5v0__filltie
XFILLER_87_392 VDD VDD VSS VSS gf180mcu_fd_sc_mcu7t5v0__fill_1
XFILLER_47_234 VDD VDD VSS VSS gf180mcu_fd_sc_mcu7t5v0__fillcap_32
XFILLER_90_524 VDD VDD VSS VSS gf180mcu_fd_sc_mcu7t5v0__fill_1
XFILLER_35_418 VDD VDD VSS VSS gf180mcu_fd_sc_mcu7t5v0__fill_2
XFILLER_16_621 VDD VDD VSS VSS gf180mcu_fd_sc_mcu7t5v0__fillcap_4
XFILLER_28_481 VDD VDD VSS VSS gf180mcu_fd_sc_mcu7t5v0__fill_1
XFILLER_46_94 VDD VDD VSS VSS gf180mcu_fd_sc_mcu7t5v0__fillcap_8
XFILLER_15_142 VDD VDD VSS VSS gf180mcu_fd_sc_mcu7t5v0__fillcap_16
XFILLER_31_602 VDD VDD VSS VSS gf180mcu_fd_sc_mcu7t5v0__fill_2
XFILLER_16_687 VDD VDD VSS VSS gf180mcu_fd_sc_mcu7t5v0__fill_1
XTAP_TAPCELL_ROW_54_991 VDD VSS gf180mcu_fd_sc_mcu7t5v0__filltie
XFILLER_129_512 VDD VDD VSS VSS gf180mcu_fd_sc_mcu7t5v0__fill_2
XFILLER_129_556 VDD VDD VSS VSS gf180mcu_fd_sc_mcu7t5v0__fillcap_4
XFILLER_12_893 VDD VDD VSS VSS gf180mcu_fd_sc_mcu7t5v0__fillcap_4
XFILLER_7_352 VDD VDD VSS VSS gf180mcu_fd_sc_mcu7t5v0__fillcap_32
X_3341_ _3263_/Z _3341_/A2 _3354_/B _3347_/B VDD VDD VSS VSS gf180mcu_fd_sc_mcu7t5v0__nand3_1
XFILLER_3_580 VDD VDD VSS VSS gf180mcu_fd_sc_mcu7t5v0__fillcap_4
X_3272_ _4062_/Q _4063_/Q _3274_/A2 VDD VDD VSS VSS gf180mcu_fd_sc_mcu7t5v0__nand2_1
XFILLER_39_702 VDD VDD VSS VSS gf180mcu_fd_sc_mcu7t5v0__fillcap_16
X_2223_ _2223_/A1 _2223_/A2 _2223_/ZN VDD VDD VSS VSS gf180mcu_fd_sc_mcu7t5v0__nand2_1
XFILLER_78_381 VDD VDD VSS VSS gf180mcu_fd_sc_mcu7t5v0__fillcap_4
XFILLER_23_2 VDD VDD VSS VSS gf180mcu_fd_sc_mcu7t5v0__fillcap_64
X_2154_ _2181_/A3 _2154_/A2 _2155_/C VDD VDD VSS VSS gf180mcu_fd_sc_mcu7t5v0__nor2_1
XFILLER_66_543 VDD VDD VSS VSS gf180mcu_fd_sc_mcu7t5v0__fillcap_8
XFILLER_93_362 VDD VDD VSS VSS gf180mcu_fd_sc_mcu7t5v0__fillcap_32
XFILLER_54_727 VDD VDD VSS VSS gf180mcu_fd_sc_mcu7t5v0__fillcap_8
X_2085_ _4145_/Q _2085_/A2 _2085_/Z VDD VDD VSS VSS gf180mcu_fd_sc_mcu7t5v0__xor2_1
XFILLER_19_492 VDD VDD VSS VSS gf180mcu_fd_sc_mcu7t5v0__fillcap_32
XFILLER_34_473 VDD VDD VSS VSS gf180mcu_fd_sc_mcu7t5v0__fillcap_8
XFILLER_50_933 VDD VDD VSS VSS gf180mcu_fd_sc_mcu7t5v0__fill_1
XFILLER_22_657 VDD VDD VSS VSS gf180mcu_fd_sc_mcu7t5v0__fillcap_8
X_2987_ _3938_/Q place85/Z _3041_/S _3938_/D VDD VDD VSS VSS gf180mcu_fd_sc_mcu7t5v0__mux2_2
X_1938_ _2903_/A1 _1938_/A2 _1938_/B _1944_/B VDD VDD VSS VSS gf180mcu_fd_sc_mcu7t5v0__oai21_1
XTAP_TAPCELL_ROW_32_696 VDD VSS gf180mcu_fd_sc_mcu7t5v0__filltie
XFILLER_107_206 VDD VDD VSS VSS gf180mcu_fd_sc_mcu7t5v0__fillcap_4
X_1869_ _2881_/A1 _4135_/Q _4134_/Q _1872_/A3 _1873_/A2 VDD VDD VSS VSS gf180mcu_fd_sc_mcu7t5v0__oai22_1
X_3608_ _4063_/Q _4064_/Q _3607_/Z _3609_/S VDD VDD VSS VSS gf180mcu_fd_sc_mcu7t5v0__nor3_1
XFILLER_107_34 VDD VDD VSS VSS gf180mcu_fd_sc_mcu7t5v0__fill_2
XFILLER_88_101 VDD VDD VSS VSS gf180mcu_fd_sc_mcu7t5v0__fillcap_4
XTAP_TAPCELL_ROW_73_1234 VDD VSS gf180mcu_fd_sc_mcu7t5v0__filltie
X_3539_ _2578_/Z _3542_/A3 _3540_/A2 VDD VDD VSS VSS gf180mcu_fd_sc_mcu7t5v0__nand2_1
XFILLER_130_242 VDD VDD VSS VSS gf180mcu_fd_sc_mcu7t5v0__fill_2
XFILLER_107_67 VDD VDD VSS VSS gf180mcu_fd_sc_mcu7t5v0__fill_2
XTAP_TAPCELL_ROW_4_333 VDD VSS gf180mcu_fd_sc_mcu7t5v0__filltie
XFILLER_29_201 VDD VDD VSS VSS gf180mcu_fd_sc_mcu7t5v0__fillcap_8
XFILLER_29_212 VDD VDD VSS VSS gf180mcu_fd_sc_mcu7t5v0__fill_2
XFILLER_69_370 VDD VDD VSS VSS gf180mcu_fd_sc_mcu7t5v0__fill_1
XTAP_TAPCELL_ROW_4_344 VDD VSS gf180mcu_fd_sc_mcu7t5v0__filltie
XFILLER_57_532 VDD VDD VSS VSS gf180mcu_fd_sc_mcu7t5v0__fill_2
XFILLER_57_543 VDD VDD VSS VSS gf180mcu_fd_sc_mcu7t5v0__fillcap_4
XFILLER_57_554 VDD VDD VSS VSS gf180mcu_fd_sc_mcu7t5v0__fillcap_4
XTAP_TAPCELL_ROW_125_1909 VDD VSS gf180mcu_fd_sc_mcu7t5v0__filltie
XFILLER_123_66 VDD VDD VSS VSS gf180mcu_fd_sc_mcu7t5v0__fillcap_4
XFILLER_84_384 VDD VDD VSS VSS gf180mcu_fd_sc_mcu7t5v0__fill_1
XTAP_TAPCELL_ROW_84_1374 VDD VSS gf180mcu_fd_sc_mcu7t5v0__filltie
XFILLER_13_613 VDD VDD VSS VSS gf180mcu_fd_sc_mcu7t5v0__fillcap_4
XFILLER_16_97 VDD VDD VSS VSS gf180mcu_fd_sc_mcu7t5v0__fillcap_8
XFILLER_12_123 VDD VDD VSS VSS gf180mcu_fd_sc_mcu7t5v0__fillcap_4
XTAP_TAPCELL_ROW_51_950 VDD VSS gf180mcu_fd_sc_mcu7t5v0__filltie
XFILLER_110_916 VDD VDD VSS VSS gf180mcu_fd_sc_mcu7t5v0__fillcap_16
XFILLER_79_156 VDD VDD VSS VSS gf180mcu_fd_sc_mcu7t5v0__fill_1
XFILLER_94_104 VDD VDD VSS VSS gf180mcu_fd_sc_mcu7t5v0__fill_1
XFILLER_75_340 VDD VDD VSS VSS gf180mcu_fd_sc_mcu7t5v0__fill_2
XFILLER_90_354 VDD VDD VSS VSS gf180mcu_fd_sc_mcu7t5v0__fillcap_16
XFILLER_16_451 VDD VDD VSS VSS gf180mcu_fd_sc_mcu7t5v0__fillcap_4
XFILLER_35_259 VDD VDD VSS VSS gf180mcu_fd_sc_mcu7t5v0__fillcap_16
XFILLER_90_387 VDD VDD VSS VSS gf180mcu_fd_sc_mcu7t5v0__fill_1
XFILLER_32_933 VDD VDD VSS VSS gf180mcu_fd_sc_mcu7t5v0__fill_1
X_2910_ place89/Z _3902_/Q _2972_/S _3902_/D VDD VDD VSS VSS gf180mcu_fd_sc_mcu7t5v0__mux2_2
X_3890_ _3890_/D _4157_/RN _4127_/CLK _3890_/Q VDD VDD VSS VSS gf180mcu_fd_sc_mcu7t5v0__dffrnq_1
XFILLER_129_320 VDD VDD VSS VSS gf180mcu_fd_sc_mcu7t5v0__fillcap_4
X_2772_ place88/Z _3839_/Q _2782_/S _3839_/D VDD VDD VSS VSS gf180mcu_fd_sc_mcu7t5v0__mux2_2
XFILLER_8_661 VDD VDD VSS VSS gf180mcu_fd_sc_mcu7t5v0__fillcap_4
XFILLER_117_559 VDD VDD VSS VSS gf180mcu_fd_sc_mcu7t5v0__fill_1
XFILLER_117_537 VDD VDD VSS VSS gf180mcu_fd_sc_mcu7t5v0__fillcap_16
XFILLER_132_507 VDD VDD VSS VSS gf180mcu_fd_sc_mcu7t5v0__fill_2
XFILLER_98_443 VDD VDD VSS VSS gf180mcu_fd_sc_mcu7t5v0__fillcap_8
X_3324_ _4084_/Q _3371_/A2 _3370_/A1 _3316_/Z _3326_/B1 VDD VDD VSS VSS gf180mcu_fd_sc_mcu7t5v0__nor4_1
XFILLER_101_927 VDD VDD VSS VSS gf180mcu_fd_sc_mcu7t5v0__fillcap_4
X_3255_ _4078_/Q _3253_/Z _3255_/B _3256_/A3 VDD VDD VSS VSS gf180mcu_fd_sc_mcu7t5v0__aoi21_1
X_2206_ _3907_/Q place72/Z _2208_/A2 VDD VDD VSS VSS gf180mcu_fd_sc_mcu7t5v0__nand2_1
XFILLER_94_660 VDD VDD VSS VSS gf180mcu_fd_sc_mcu7t5v0__fillcap_4
XFILLER_82_811 VDD VDD VSS VSS gf180mcu_fd_sc_mcu7t5v0__fill_1
XTAP_TAPCELL_ROW_1_303 VDD VSS gf180mcu_fd_sc_mcu7t5v0__filltie
XFILLER_39_554 VDD VDD VSS VSS gf180mcu_fd_sc_mcu7t5v0__fill_1
XFILLER_26_215 VDD VDD VSS VSS gf180mcu_fd_sc_mcu7t5v0__fill_1
XFILLER_54_524 VDD VDD VSS VSS gf180mcu_fd_sc_mcu7t5v0__fill_1
X_2068_ _2068_/A1 _2079_/A2 _2079_/A3 _2073_/A2 VDD VDD VSS VSS gf180mcu_fd_sc_mcu7t5v0__nor3_1
XFILLER_82_877 VDD VDD VSS VSS gf180mcu_fd_sc_mcu7t5v0__fillcap_8
XTAP_TAPCELL_ROW_37_766 VDD VSS gf180mcu_fd_sc_mcu7t5v0__filltie
XFILLER_41_229 VDD VDD VSS VSS gf180mcu_fd_sc_mcu7t5v0__fillcap_32
XTAP_TAPCELL_ROW_9_403 VDD VSS gf180mcu_fd_sc_mcu7t5v0__filltie
XFILLER_1_325 VDD VDD VSS VSS gf180mcu_fd_sc_mcu7t5v0__fillcap_16
XFILLER_131_562 VDD VDD VSS VSS gf180mcu_fd_sc_mcu7t5v0__fill_1
XFILLER_77_627 VDD VDD VSS VSS gf180mcu_fd_sc_mcu7t5v0__fill_2
XFILLER_76_104 VDD VDD VSS VSS gf180mcu_fd_sc_mcu7t5v0__fill_1
XTAP_TAPCELL_ROW_86_1403 VDD VSS gf180mcu_fd_sc_mcu7t5v0__filltie
XFILLER_58_874 VDD VDD VSS VSS gf180mcu_fd_sc_mcu7t5v0__fill_1
XFILLER_58_863 VDD VDD VSS VSS gf180mcu_fd_sc_mcu7t5v0__fill_1
XFILLER_72_321 VDD VDD VSS VSS gf180mcu_fd_sc_mcu7t5v0__fill_1
XFILLER_45_557 VDD VDD VSS VSS gf180mcu_fd_sc_mcu7t5v0__fill_2
XFILLER_45_568 VDD VDD VSS VSS gf180mcu_fd_sc_mcu7t5v0__fill_1
XFILLER_14_933 VDD VDD VSS VSS gf180mcu_fd_sc_mcu7t5v0__fill_1
XFILLER_60_527 VDD VDD VSS VSS gf180mcu_fd_sc_mcu7t5v0__fillcap_32
XFILLER_72_376 VDD VDD VSS VSS gf180mcu_fd_sc_mcu7t5v0__fillcap_8
XFILLER_72_387 VDD VDD VSS VSS gf180mcu_fd_sc_mcu7t5v0__fillcap_64
XFILLER_126_301 VDD VDD VSS VSS gf180mcu_fd_sc_mcu7t5v0__fillcap_4
XTAP_TAPCELL_ROW_97_1543 VDD VSS gf180mcu_fd_sc_mcu7t5v0__filltie
XFILLER_114_507 VDD VDD VSS VSS gf180mcu_fd_sc_mcu7t5v0__fill_1
XFILLER_5_697 VDD VDD VSS VSS gf180mcu_fd_sc_mcu7t5v0__fill_2
XFILLER_4_185 VDD VDD VSS VSS gf180mcu_fd_sc_mcu7t5v0__fill_2
XFILLER_122_540 VDD VDD VSS VSS gf180mcu_fd_sc_mcu7t5v0__fillcap_8
XFILLER_96_925 VDD VDD VSS VSS gf180mcu_fd_sc_mcu7t5v0__fillcap_8
XFILLER_95_446 VDD VDD VSS VSS gf180mcu_fd_sc_mcu7t5v0__fillcap_4
XFILLER_82_107 VDD VDD VSS VSS gf180mcu_fd_sc_mcu7t5v0__fillcap_8
XFILLER_76_660 VDD VDD VSS VSS gf180mcu_fd_sc_mcu7t5v0__fillcap_4
XFILLER_75_170 VDD VDD VSS VSS gf180mcu_fd_sc_mcu7t5v0__fill_2
XFILLER_36_535 VDD VDD VSS VSS gf180mcu_fd_sc_mcu7t5v0__fillcap_4
XFILLER_64_877 VDD VDD VSS VSS gf180mcu_fd_sc_mcu7t5v0__fillcap_16
XTAP_TAPCELL_ROW_106_1661 VDD VSS gf180mcu_fd_sc_mcu7t5v0__filltie
XTAP_TAPCELL_ROW_34_725 VDD VSS gf180mcu_fd_sc_mcu7t5v0__filltie
X_3942_ _3942_/D _4157_/RN _3976_/CLK _3942_/Q VDD VDD VSS VSS gf180mcu_fd_sc_mcu7t5v0__dffrnq_1
XFILLER_20_925 VDD VDD VSS VSS gf180mcu_fd_sc_mcu7t5v0__fillcap_8
X_3873_ _3873_/D _4115_/CLK _3873_/Q VDD VDD VSS VSS gf180mcu_fd_sc_mcu7t5v0__dffq_1
XTAP_TAPCELL_ROW_14_471 VDD VSS gf180mcu_fd_sc_mcu7t5v0__filltie
XFILLER_117_345 VDD VDD VSS VSS gf180mcu_fd_sc_mcu7t5v0__fillcap_4
XFILLER_105_507 VDD VDD VSS VSS gf180mcu_fd_sc_mcu7t5v0__fillcap_32
XTAP_TAPCELL_ROW_57_1026 VDD VSS gf180mcu_fd_sc_mcu7t5v0__filltie
XFILLER_99_741 VDD VDD VSS VSS gf180mcu_fd_sc_mcu7t5v0__fillcap_16
XFILLER_113_562 VDD VDD VSS VSS gf180mcu_fd_sc_mcu7t5v0__fillcap_8
XFILLER_101_702 VDD VDD VSS VSS gf180mcu_fd_sc_mcu7t5v0__fillcap_64
X_3307_ place80/Z _4166_/Q _4157_/D _4072_/D VDD VDD VSS VSS gf180mcu_fd_sc_mcu7t5v0__mux2_2
XFILLER_104_68 VDD VDD VSS VSS gf180mcu_fd_sc_mcu7t5v0__fillcap_32
XFILLER_100_289 VDD VDD VSS VSS gf180mcu_fd_sc_mcu7t5v0__fillcap_16
XFILLER_66_170 VDD VDD VSS VSS gf180mcu_fd_sc_mcu7t5v0__fillcap_4
X_3169_ _4024_/Q _3992_/Q _4129_/D _4024_/D VDD VDD VSS VSS gf180mcu_fd_sc_mcu7t5v0__mux2_2
XPHY_EDGE_ROW_126_Right_126 VDD VSS gf180mcu_fd_sc_mcu7t5v0__endcap
XFILLER_54_376 VDD VDD VSS VSS gf180mcu_fd_sc_mcu7t5v0__fillcap_8
XFILLER_54_387 VDD VDD VSS VSS gf180mcu_fd_sc_mcu7t5v0__fillcap_16
XTAP_TAPCELL_ROW_68_1166 VDD VSS gf180mcu_fd_sc_mcu7t5v0__filltie
XFILLER_70_836 VDD VDD VSS VSS gf180mcu_fd_sc_mcu7t5v0__fillcap_8
XTAP_TAPCELL_ROW_81_1333 VDD VSS gf180mcu_fd_sc_mcu7t5v0__filltie
XTAP_TAPCELL_ROW_81_1344 VDD VSS gf180mcu_fd_sc_mcu7t5v0__filltie
XFILLER_80_27 VDD VDD VSS VSS gf180mcu_fd_sc_mcu7t5v0__fillcap_8
XFILLER_23_763 VDD VDD VSS VSS gf180mcu_fd_sc_mcu7t5v0__fillcap_4
XFILLER_10_457 VDD VDD VSS VSS gf180mcu_fd_sc_mcu7t5v0__fillcap_64
XFILLER_109_857 VDD VDD VSS VSS gf180mcu_fd_sc_mcu7t5v0__fillcap_16
XFILLER_124_827 VDD VDD VSS VSS gf180mcu_fd_sc_mcu7t5v0__fill_1
XFILLER_2_623 VDD VDD VSS VSS gf180mcu_fd_sc_mcu7t5v0__fill_1
XFILLER_2_667 VDD VDD VSS VSS gf180mcu_fd_sc_mcu7t5v0__fillcap_16
XTAP_TAPCELL_ROW_92_1484 VDD VSS gf180mcu_fd_sc_mcu7t5v0__filltie
XFILLER_46_800 VDD VDD VSS VSS gf180mcu_fd_sc_mcu7t5v0__fillcap_4
XFILLER_46_877 VDD VDD VSS VSS gf180mcu_fd_sc_mcu7t5v0__fillcap_16
XFILLER_73_696 VDD VDD VSS VSS gf180mcu_fd_sc_mcu7t5v0__fillcap_4
XFILLER_45_376 VDD VDD VSS VSS gf180mcu_fd_sc_mcu7t5v0__fill_2
XFILLER_54_61 VDD VDD VSS VSS gf180mcu_fd_sc_mcu7t5v0__fillcap_32
XFILLER_61_858 VDD VDD VSS VSS gf180mcu_fd_sc_mcu7t5v0__fillcap_4
XFILLER_9_200 VDD VDD VSS VSS gf180mcu_fd_sc_mcu7t5v0__fillcap_8
XFILLER_14_785 VDD VDD VSS VSS gf180mcu_fd_sc_mcu7t5v0__fill_2
XTAP_TAPCELL_ROW_11_430 VDD VSS gf180mcu_fd_sc_mcu7t5v0__filltie
XFILLER_9_277 VDD VDD VSS VSS gf180mcu_fd_sc_mcu7t5v0__fill_2
XFILLER_9_244 VDD VDD VSS VSS gf180mcu_fd_sc_mcu7t5v0__fill_2
XFILLER_127_632 VDD VDD VSS VSS gf180mcu_fd_sc_mcu7t5v0__fillcap_8
Xclkload25 _4130_/CLK clkload25/ZN VDD VDD VSS VSS gf180mcu_fd_sc_mcu7t5v0__clkinv_2
Xclkload14 _3806_/CLK clkload14/Z VDD VDD VSS VSS gf180mcu_fd_sc_mcu7t5v0__clkbuf_8
Xclkload47 _3975_/CLK clkload47/Z VDD VDD VSS VSS gf180mcu_fd_sc_mcu7t5v0__clkbuf_4
X_2540_ _2540_/A1 _2558_/A1 place55/I VDD VDD VSS VSS gf180mcu_fd_sc_mcu7t5v0__nor2_1
Xclkload36 _4076_/CLK clkload36/Z VDD VDD VSS VSS gf180mcu_fd_sc_mcu7t5v0__clkbuf_2
XFILLER_127_698 VDD VDD VSS VSS gf180mcu_fd_sc_mcu7t5v0__fill_2
X_2471_ _3709_/Q place82/Z _2485_/S _3709_/D VDD VDD VSS VSS gf180mcu_fd_sc_mcu7t5v0__mux2_2
XFILLER_114_359 VDD VDD VSS VSS gf180mcu_fd_sc_mcu7t5v0__fill_2
XFILLER_79_80 VDD VDD VSS VSS gf180mcu_fd_sc_mcu7t5v0__fillcap_4
XFILLER_96_722 VDD VDD VSS VSS gf180mcu_fd_sc_mcu7t5v0__fillcap_8
XFILLER_110_521 VDD VDD VSS VSS gf180mcu_fd_sc_mcu7t5v0__fillcap_4
X_4141_ _4141_/D _4148_/RN _4145_/CLK _4141_/Q VDD VDD VSS VSS gf180mcu_fd_sc_mcu7t5v0__dffrnq_1
XFILLER_84_928 VDD VDD VSS VSS gf180mcu_fd_sc_mcu7t5v0__fillcap_4
XFILLER_83_405 VDD VDD VSS VSS gf180mcu_fd_sc_mcu7t5v0__fill_1
X_4072_ _4072_/D input92/Z _4072_/CLK _4072_/Q VDD VDD VSS VSS gf180mcu_fd_sc_mcu7t5v0__dffrnq_1
XFILLER_68_457 VDD VDD VSS VSS gf180mcu_fd_sc_mcu7t5v0__fillcap_8
X_3023_ _3955_/Q _4043_/Q _3041_/S _3955_/D VDD VDD VSS VSS gf180mcu_fd_sc_mcu7t5v0__mux2_2
XFILLER_48_170 VDD VDD VSS VSS gf180mcu_fd_sc_mcu7t5v0__fillcap_4
XTAP_TAPCELL_ROW_19_530 VDD VSS gf180mcu_fd_sc_mcu7t5v0__filltie
XFILLER_91_471 VDD VDD VSS VSS gf180mcu_fd_sc_mcu7t5v0__fill_1
XFILLER_24_527 VDD VDD VSS VSS gf180mcu_fd_sc_mcu7t5v0__fillcap_32
XFILLER_36_387 VDD VDD VSS VSS gf180mcu_fd_sc_mcu7t5v0__fill_2
XTAP_TAPCELL_ROW_47_894 VDD VSS gf180mcu_fd_sc_mcu7t5v0__filltie
XFILLER_52_869 VDD VDD VSS VSS gf180mcu_fd_sc_mcu7t5v0__fillcap_4
X_3925_ _3925_/D _2279_/I _4125_/CLK _3925_/Q VDD VDD VSS VSS gf180mcu_fd_sc_mcu7t5v0__dffrnq_1
X_3856_ _3856_/D _3864_/CLK _3856_/Q VDD VDD VSS VSS gf180mcu_fd_sc_mcu7t5v0__dffq_1
Xclkload8 clkload8/I clkload8/ZN VDD VDD VSS VSS gf180mcu_fd_sc_mcu7t5v0__clkinv_2
XTAP_TAPCELL_ROW_119_1830 VDD VSS gf180mcu_fd_sc_mcu7t5v0__filltie
X_3787_ _3787_/D clkload7/I _3787_/Q VDD VDD VSS VSS gf180mcu_fd_sc_mcu7t5v0__dffq_1
XFILLER_118_654 VDD VDD VSS VSS gf180mcu_fd_sc_mcu7t5v0__fillcap_8
XFILLER_117_142 VDD VDD VSS VSS gf180mcu_fd_sc_mcu7t5v0__fillcap_16
X_2738_ _3824_/Q place87/Z _2746_/S _3824_/D VDD VDD VSS VSS gf180mcu_fd_sc_mcu7t5v0__mux2_2
XFILLER_132_101 VDD VDD VSS VSS gf180mcu_fd_sc_mcu7t5v0__fill_1
XFILLER_105_348 VDD VDD VSS VSS gf180mcu_fd_sc_mcu7t5v0__fill_2
XFILLER_114_871 VDD VDD VSS VSS gf180mcu_fd_sc_mcu7t5v0__fillcap_4
XFILLER_113_370 VDD VDD VSS VSS gf180mcu_fd_sc_mcu7t5v0__fillcap_4
XFILLER_86_221 VDD VDD VSS VSS gf180mcu_fd_sc_mcu7t5v0__fillcap_8
XFILLER_115_67 VDD VDD VSS VSS gf180mcu_fd_sc_mcu7t5v0__fill_2
XFILLER_87_766 VDD VDD VSS VSS gf180mcu_fd_sc_mcu7t5v0__fillcap_4
XFILLER_75_928 VDD VDD VSS VSS gf180mcu_fd_sc_mcu7t5v0__fillcap_4
XFILLER_75_906 VDD VDD VSS VSS gf180mcu_fd_sc_mcu7t5v0__fillcap_4
XFILLER_47_619 VDD VDD VSS VSS gf180mcu_fd_sc_mcu7t5v0__fillcap_8
XFILLER_59_468 VDD VDD VSS VSS gf180mcu_fd_sc_mcu7t5v0__fillcap_8
XFILLER_28_811 VDD VDD VSS VSS gf180mcu_fd_sc_mcu7t5v0__fill_2
XFILLER_46_107 VDD VDD VSS VSS gf180mcu_fd_sc_mcu7t5v0__fillcap_8
XFILLER_90_909 VDD VDD VSS VSS gf180mcu_fd_sc_mcu7t5v0__fillcap_16
XFILLER_27_343 VDD VDD VSS VSS gf180mcu_fd_sc_mcu7t5v0__fillcap_4
XFILLER_28_877 VDD VDD VSS VSS gf180mcu_fd_sc_mcu7t5v0__fillcap_32
XFILLER_43_836 VDD VDD VSS VSS gf180mcu_fd_sc_mcu7t5v0__fillcap_4
XFILLER_55_696 VDD VDD VSS VSS gf180mcu_fd_sc_mcu7t5v0__fillcap_4
XFILLER_131_88 VDD VDD VSS VSS gf180mcu_fd_sc_mcu7t5v0__fillcap_4
XFILLER_91_59 VDD VDD VSS VSS gf180mcu_fd_sc_mcu7t5v0__fillcap_8
XPHY_EDGE_ROW_59_Left_192 VDD VSS gf180mcu_fd_sc_mcu7t5v0__endcap
XFILLER_70_699 VDD VDD VSS VSS gf180mcu_fd_sc_mcu7t5v0__fillcap_32
XFILLER_109_632 VDD VDD VSS VSS gf180mcu_fd_sc_mcu7t5v0__fillcap_64
XTAP_TAPCELL_ROW_94_1513 VDD VSS gf180mcu_fd_sc_mcu7t5v0__filltie
XTAP_TAPCELL_ROW_94_1502 VDD VSS gf180mcu_fd_sc_mcu7t5v0__filltie
XFILLER_10_298 VDD VDD VSS VSS gf180mcu_fd_sc_mcu7t5v0__fill_2
XFILLER_6_247 VDD VDD VSS VSS gf180mcu_fd_sc_mcu7t5v0__fillcap_64
XFILLER_108_164 VDD VDD VSS VSS gf180mcu_fd_sc_mcu7t5v0__fillcap_8
XFILLER_40_85 VDD VDD VSS VSS gf180mcu_fd_sc_mcu7t5v0__fillcap_4
XFILLER_3_932 VDD VDD VSS VSS gf180mcu_fd_sc_mcu7t5v0__fill_2
XFILLER_2_497 VDD VDD VSS VSS gf180mcu_fd_sc_mcu7t5v0__fillcap_4
XFILLER_49_72 VDD VDD VSS VSS gf180mcu_fd_sc_mcu7t5v0__fillcap_64
XFILLER_65_416 VDD VDD VSS VSS gf180mcu_fd_sc_mcu7t5v0__fillcap_4
XFILLER_65_438 VDD VDD VSS VSS gf180mcu_fd_sc_mcu7t5v0__fillcap_8
XFILLER_1_68 VDD VDD VSS VSS gf180mcu_fd_sc_mcu7t5v0__fill_2
Xclkbuf_leaf_57_clk clkbuf_leaf_5_clk/I _3806_/CLK VDD VDD VSS VSS gf180mcu_fd_sc_mcu7t5v0__clkbuf_8
XFILLER_46_641 VDD VDD VSS VSS gf180mcu_fd_sc_mcu7t5v0__fill_1
XTAP_TAPCELL_ROW_103_1620 VDD VSS gf180mcu_fd_sc_mcu7t5v0__filltie
XFILLER_18_387 VDD VDD VSS VSS gf180mcu_fd_sc_mcu7t5v0__fillcap_4
XTAP_TAPCELL_ROW_16_500 VDD VSS gf180mcu_fd_sc_mcu7t5v0__filltie
XTAP_TAPCELL_ROW_103_1631 VDD VSS gf180mcu_fd_sc_mcu7t5v0__filltie
XTAP_TAPCELL_ROW_44_853 VDD VSS gf180mcu_fd_sc_mcu7t5v0__filltie
XTAP_TAPCELL_ROW_44_864 VDD VSS gf180mcu_fd_sc_mcu7t5v0__filltie
X_1971_ _4130_/Q _1972_/A2 VDD VDD VSS VSS gf180mcu_fd_sc_mcu7t5v0__clkinv_1
X_3710_ _3710_/D _3740_/CLK _3710_/Q VDD VDD VSS VSS gf180mcu_fd_sc_mcu7t5v0__dffq_1
XFILLER_61_699 VDD VDD VSS VSS gf180mcu_fd_sc_mcu7t5v0__fill_1
XFILLER_119_418 VDD VDD VSS VSS gf180mcu_fd_sc_mcu7t5v0__fill_2
X_3641_ _3641_/D _4108_/CLK _3641_/Q VDD VDD VSS VSS gf180mcu_fd_sc_mcu7t5v0__dffq_1
XTAP_TAPCELL_ROW_132_2016 VDD VSS gf180mcu_fd_sc_mcu7t5v0__filltie
XTAP_TAPCELL_ROW_132_2005 VDD VSS gf180mcu_fd_sc_mcu7t5v0__filltie
X_3572_ _3571_/Z _4152_/Q _3600_/S _4152_/D VDD VDD VSS VSS gf180mcu_fd_sc_mcu7t5v0__mux2_2
X_2523_ _4097_/Q _3414_/A1 _2523_/A3 _2538_/S VDD VDD VSS VSS gf180mcu_fd_sc_mcu7t5v0__nand3_2
XFILLER_114_123 VDD VDD VSS VSS gf180mcu_fd_sc_mcu7t5v0__fillcap_8
XTAP_TAPCELL_ROW_114_1771 VDD VSS gf180mcu_fd_sc_mcu7t5v0__filltie
X_2454_ _4068_/Q _3702_/Q _2466_/S _3702_/D VDD VDD VSS VSS gf180mcu_fd_sc_mcu7t5v0__mux2_2
X_2385_ _3671_/Q _4069_/Q _2395_/S _3671_/D VDD VDD VSS VSS gf180mcu_fd_sc_mcu7t5v0__mux2_2
XFILLER_111_874 VDD VDD VSS VSS gf180mcu_fd_sc_mcu7t5v0__fillcap_16
X_4124_ _4124_/D _4157_/RN _4127_/CLK _4124_/Q VDD VDD VSS VSS gf180mcu_fd_sc_mcu7t5v0__dffrnq_1
XFILLER_57_906 VDD VDD VSS VSS gf180mcu_fd_sc_mcu7t5v0__fillcap_4
XFILLER_57_928 VDD VDD VSS VSS gf180mcu_fd_sc_mcu7t5v0__fillcap_4
XFILLER_83_202 VDD VDD VSS VSS gf180mcu_fd_sc_mcu7t5v0__fillcap_8
XFILLER_28_107 VDD VDD VSS VSS gf180mcu_fd_sc_mcu7t5v0__fillcap_32
XFILLER_68_287 VDD VDD VSS VSS gf180mcu_fd_sc_mcu7t5v0__fillcap_4
X_4055_ _4055_/D _4148_/RN _4115_/CLK _4055_/Q VDD VDD VSS VSS gf180mcu_fd_sc_mcu7t5v0__dffrnq_1
Xclkbuf_leaf_48_clk clkload3/I _4109_/CLK VDD VDD VSS VSS gf180mcu_fd_sc_mcu7t5v0__clkbuf_8
X_3006_ _3947_/Q _4035_/Q _3041_/S _3947_/D VDD VDD VSS VSS gf180mcu_fd_sc_mcu7t5v0__mux2_2
XFILLER_83_279 VDD VDD VSS VSS gf180mcu_fd_sc_mcu7t5v0__fill_1
XFILLER_36_173 VDD VDD VSS VSS gf180mcu_fd_sc_mcu7t5v0__fill_2
XFILLER_37_696 VDD VDD VSS VSS gf180mcu_fd_sc_mcu7t5v0__fillcap_4
XFILLER_52_633 VDD VDD VSS VSS gf180mcu_fd_sc_mcu7t5v0__fill_1
XTAP_TAPCELL_ROW_65_1125 VDD VSS gf180mcu_fd_sc_mcu7t5v0__filltie
XTAP_TAPCELL_ROW_65_1136 VDD VSS gf180mcu_fd_sc_mcu7t5v0__filltie
XFILLER_51_154 VDD VDD VSS VSS gf180mcu_fd_sc_mcu7t5v0__fill_2
X_3908_ _3908_/D _2279_/I _4114_/CLK _3908_/Q VDD VDD VSS VSS gf180mcu_fd_sc_mcu7t5v0__dffrnq_1
X_3839_ _3839_/D _3865_/CLK _3839_/Q VDD VDD VSS VSS gf180mcu_fd_sc_mcu7t5v0__dffq_1
XTAP_TAPCELL_ROW_22_569 VDD VSS gf180mcu_fd_sc_mcu7t5v0__filltie
XFILLER_118_473 VDD VDD VSS VSS gf180mcu_fd_sc_mcu7t5v0__fillcap_4
XFILLER_3_206 VDD VDD VSS VSS gf180mcu_fd_sc_mcu7t5v0__fillcap_4
XFILLER_105_134 VDD VDD VSS VSS gf180mcu_fd_sc_mcu7t5v0__fillcap_4
XFILLER_105_112 VDD VDD VSS VSS gf180mcu_fd_sc_mcu7t5v0__fillcap_4
XTAP_TAPCELL_ROW_76_1276 VDD VSS gf180mcu_fd_sc_mcu7t5v0__filltie
XFILLER_10_33 VDD VDD VSS VSS gf180mcu_fd_sc_mcu7t5v0__fill_2
XFILLER_120_104 VDD VDD VSS VSS gf180mcu_fd_sc_mcu7t5v0__fill_1
XFILLER_120_115 VDD VDD VSS VSS gf180mcu_fd_sc_mcu7t5v0__fill_2
XFILLER_75_725 VDD VDD VSS VSS gf180mcu_fd_sc_mcu7t5v0__fillcap_4
XFILLER_47_416 VDD VDD VSS VSS gf180mcu_fd_sc_mcu7t5v0__fillcap_4
XFILLER_59_276 VDD VDD VSS VSS gf180mcu_fd_sc_mcu7t5v0__fillcap_4
XFILLER_75_758 VDD VDD VSS VSS gf180mcu_fd_sc_mcu7t5v0__fillcap_8
XFILLER_74_224 VDD VDD VSS VSS gf180mcu_fd_sc_mcu7t5v0__fillcap_16
Xclkbuf_leaf_39_clk clkload4/I _3740_/CLK VDD VDD VSS VSS gf180mcu_fd_sc_mcu7t5v0__clkbuf_8
XFILLER_27_173 VDD VDD VSS VSS gf180mcu_fd_sc_mcu7t5v0__fillcap_32
XPHY_EDGE_ROW_67_Left_200 VDD VSS gf180mcu_fd_sc_mcu7t5v0__endcap
XFILLER_30_305 VDD VDD VSS VSS gf180mcu_fd_sc_mcu7t5v0__fillcap_8
XTAP_TAPCELL_ROW_41_823 VDD VSS gf180mcu_fd_sc_mcu7t5v0__filltie
XFILLER_7_556 VDD VDD VSS VSS gf180mcu_fd_sc_mcu7t5v0__fillcap_4
XFILLER_39_906 VDD VDD VSS VSS gf180mcu_fd_sc_mcu7t5v0__fillcap_4
XFILLER_39_928 VDD VDD VSS VSS gf180mcu_fd_sc_mcu7t5v0__fillcap_4
XFILLER_93_500 VDD VDD VSS VSS gf180mcu_fd_sc_mcu7t5v0__fillcap_8
X_2170_ _2170_/A1 _2170_/A2 _2170_/A3 _2170_/ZN VDD VDD VSS VSS gf180mcu_fd_sc_mcu7t5v0__nand3_1
XFILLER_78_574 VDD VDD VSS VSS gf180mcu_fd_sc_mcu7t5v0__fillcap_4
XTAP_TAPCELL_ROW_49_923 VDD VSS gf180mcu_fd_sc_mcu7t5v0__filltie
XFILLER_65_268 VDD VDD VSS VSS gf180mcu_fd_sc_mcu7t5v0__fillcap_8
Xplace91 _3905_/Q place91/Z VDD VDD VSS VSS gf180mcu_fd_sc_mcu7t5v0__buf_8
Xplace80 _4072_/Q place80/Z VDD VDD VSS VSS gf180mcu_fd_sc_mcu7t5v0__buf_8
XFILLER_46_493 VDD VDD VSS VSS gf180mcu_fd_sc_mcu7t5v0__fillcap_4
XFILLER_62_931 VDD VDD VSS VSS gf180mcu_fd_sc_mcu7t5v0__fill_2
X_1954_ _3902_/Q _1953_/Z _3607_/A2 VDD VDD VSS VSS gf180mcu_fd_sc_mcu7t5v0__nand2_1
XFILLER_119_204 VDD VDD VSS VSS gf180mcu_fd_sc_mcu7t5v0__fillcap_4
XTAP_TAPCELL_ROW_60_1066 VDD VSS gf180mcu_fd_sc_mcu7t5v0__filltie
XTAP_TAPCELL_ROW_116_1800 VDD VSS gf180mcu_fd_sc_mcu7t5v0__filltie
X_1885_ _4136_/Q _1935_/A4 _1892_/C _4137_/Q _1899_/A1 VDD VDD VSS VSS gf180mcu_fd_sc_mcu7t5v0__aoi211_1
X_3624_ _3627_/I1 _4166_/Q _3624_/S _4166_/D VDD VDD VSS VSS gf180mcu_fd_sc_mcu7t5v0__mux2_2
X_3555_ _3870_/Q _3878_/Q _3766_/Q _3774_/Q place76/Z place75/Z _3555_/Z VDD VDD VSS
+ VSS gf180mcu_fd_sc_mcu7t5v0__mux4_1
X_3486_ _3904_/Q _4156_/Q _3487_/A2 VDD VDD VSS VSS gf180mcu_fd_sc_mcu7t5v0__nand2_1
XFILLER_102_104 VDD VDD VSS VSS gf180mcu_fd_sc_mcu7t5v0__fill_1
XFILLER_130_457 VDD VDD VSS VSS gf180mcu_fd_sc_mcu7t5v0__fillcap_16
XFILLER_111_660 VDD VDD VSS VSS gf180mcu_fd_sc_mcu7t5v0__fill_1
XFILLER_96_382 VDD VDD VSS VSS gf180mcu_fd_sc_mcu7t5v0__fill_2
X_4107_ _4107_/D _4157_/RN _4108_/CLK _4107_/Q VDD VDD VSS VSS gf180mcu_fd_sc_mcu7t5v0__dffrnq_1
XTAP_TAPCELL_ROW_127_1940 VDD VSS gf180mcu_fd_sc_mcu7t5v0__filltie
X_4038_ _4038_/D _4148_/RN _4147_/CLK _4038_/Q VDD VDD VSS VSS gf180mcu_fd_sc_mcu7t5v0__dffrnq_1
XFILLER_44_419 VDD VDD VSS VSS gf180mcu_fd_sc_mcu7t5v0__fillcap_16
XTAP_TAPCELL_ROW_27_639 VDD VSS gf180mcu_fd_sc_mcu7t5v0__filltie
XFILLER_53_931 VDD VDD VSS VSS gf180mcu_fd_sc_mcu7t5v0__fill_2
XFILLER_71_216 VDD VDD VSS VSS gf180mcu_fd_sc_mcu7t5v0__fill_2
XFILLER_71_249 VDD VDD VSS VSS gf180mcu_fd_sc_mcu7t5v0__fillcap_8
XTAP_TAPCELL_ROW_78_1305 VDD VSS gf180mcu_fd_sc_mcu7t5v0__filltie
XFILLER_125_207 VDD VDD VSS VSS gf180mcu_fd_sc_mcu7t5v0__fill_2
XFILLER_118_270 VDD VDD VSS VSS gf180mcu_fd_sc_mcu7t5v0__fill_2
XFILLER_21_87 VDD VDD VSS VSS gf180mcu_fd_sc_mcu7t5v0__fillcap_32
XFILLER_97_69 VDD VDD VSS VSS gf180mcu_fd_sc_mcu7t5v0__fill_1
XFILLER_79_349 VDD VDD VSS VSS gf180mcu_fd_sc_mcu7t5v0__fill_1
XTAP_TAPCELL_ROW_7_375 VDD VSS gf180mcu_fd_sc_mcu7t5v0__filltie
XTAP_TAPCELL_ROW_89_1445 VDD VSS gf180mcu_fd_sc_mcu7t5v0__filltie
XFILLER_63_717 VDD VDD VSS VSS gf180mcu_fd_sc_mcu7t5v0__fillcap_8
XFILLER_90_569 VDD VDD VSS VSS gf180mcu_fd_sc_mcu7t5v0__fill_1
XFILLER_71_772 VDD VDD VSS VSS gf180mcu_fd_sc_mcu7t5v0__fillcap_32
XTAP_TAPCELL_ROW_54_992 VDD VSS gf180mcu_fd_sc_mcu7t5v0__filltie
XFILLER_30_168 VDD VDD VSS VSS gf180mcu_fd_sc_mcu7t5v0__fillcap_4
XFILLER_7_67 VDD VDD VSS VSS gf180mcu_fd_sc_mcu7t5v0__fill_2
XFILLER_125_774 VDD VDD VSS VSS gf180mcu_fd_sc_mcu7t5v0__fill_1
XFILLER_124_240 VDD VDD VSS VSS gf180mcu_fd_sc_mcu7t5v0__fillcap_4
X_3340_ _4080_/Q _3340_/A2 _3319_/B _3354_/B VDD VDD VSS VSS gf180mcu_fd_sc_mcu7t5v0__nand3_1
XTAP_TAPCELL_ROW_111_1730 VDD VSS gf180mcu_fd_sc_mcu7t5v0__filltie
XFILLER_3_570 VDD VDD VSS VSS gf180mcu_fd_sc_mcu7t5v0__fillcap_4
XFILLER_97_135 VDD VDD VSS VSS gf180mcu_fd_sc_mcu7t5v0__fillcap_4
X_3271_ _3256_/Z _3263_/Z _3271_/A3 _3271_/B1 _3626_/A1 _4063_/D VDD VDD VSS VSS gf180mcu_fd_sc_mcu7t5v0__oai32_2
X_2222_ _3909_/Q place72/Z place67/Z _4085_/Q _2223_/A2 VDD VDD VSS VSS gf180mcu_fd_sc_mcu7t5v0__aoi22_1
X_2153_ _4126_/Q _2167_/A2 _2152_/Z _2185_/A1 _2154_/A2 VDD VDD VSS VSS gf180mcu_fd_sc_mcu7t5v0__aoi22_1
XFILLER_16_2 VDD VDD VSS VSS gf180mcu_fd_sc_mcu7t5v0__fillcap_32
XFILLER_27_909 VDD VDD VSS VSS gf180mcu_fd_sc_mcu7t5v0__fill_1
XFILLER_39_769 VDD VDD VSS VSS gf180mcu_fd_sc_mcu7t5v0__fill_1
XFILLER_38_279 VDD VDD VSS VSS gf180mcu_fd_sc_mcu7t5v0__fill_2
XFILLER_53_205 VDD VDD VSS VSS gf180mcu_fd_sc_mcu7t5v0__fillcap_4
X_2084_ _1835_/B _2079_/Z _2085_/A2 VDD VDD VSS VSS gf180mcu_fd_sc_mcu7t5v0__nor2_1
XFILLER_35_931 VDD VDD VSS VSS gf180mcu_fd_sc_mcu7t5v0__fill_2
XFILLER_53_227 VDD VDD VSS VSS gf180mcu_fd_sc_mcu7t5v0__fillcap_4
XFILLER_34_452 VDD VDD VSS VSS gf180mcu_fd_sc_mcu7t5v0__fill_2
XFILLER_61_271 VDD VDD VSS VSS gf180mcu_fd_sc_mcu7t5v0__fillcap_8
XTAP_TAPCELL_ROW_122_1870 VDD VSS gf180mcu_fd_sc_mcu7t5v0__filltie
XFILLER_21_135 VDD VDD VSS VSS gf180mcu_fd_sc_mcu7t5v0__fillcap_4
XFILLER_61_282 VDD VDD VSS VSS gf180mcu_fd_sc_mcu7t5v0__fillcap_8
XFILLER_21_179 VDD VDD VSS VSS gf180mcu_fd_sc_mcu7t5v0__fill_2
X_1937_ _2903_/A1 _4146_/Q _1942_/B _1938_/B VDD VDD VSS VSS gf180mcu_fd_sc_mcu7t5v0__nand3_1
XFILLER_108_708 VDD VDD VSS VSS gf180mcu_fd_sc_mcu7t5v0__fillcap_16
XFILLER_30_691 VDD VDD VSS VSS gf180mcu_fd_sc_mcu7t5v0__fill_2
XTAP_TAPCELL_ROW_32_697 VDD VSS gf180mcu_fd_sc_mcu7t5v0__filltie
X_1868_ _3885_/Q _3886_/Q _1872_/A3 VDD VDD VSS VSS gf180mcu_fd_sc_mcu7t5v0__nor2_1
X_3607_ _4062_/Q _3607_/A2 _3607_/A3 _3607_/Z VDD VDD VSS VSS gf180mcu_fd_sc_mcu7t5v0__or3_1
Xinput92 input92/I input92/Z VDD VDD VSS VSS gf180mcu_fd_sc_mcu7t5v0__buf_8
XFILLER_116_785 VDD VDD VSS VSS gf180mcu_fd_sc_mcu7t5v0__fillcap_4
XFILLER_115_273 VDD VDD VSS VSS gf180mcu_fd_sc_mcu7t5v0__fillcap_4
XTAP_TAPCELL_ROW_73_1235 VDD VSS gf180mcu_fd_sc_mcu7t5v0__filltie
X_3469_ _3474_/A1 _3464_/Z _3469_/Z VDD VDD VSS VSS gf180mcu_fd_sc_mcu7t5v0__or2_1
XFILLER_131_788 VDD VDD VSS VSS gf180mcu_fd_sc_mcu7t5v0__fill_2
XFILLER_85_842 VDD VDD VSS VSS gf180mcu_fd_sc_mcu7t5v0__fillcap_8
XTAP_TAPCELL_ROW_4_334 VDD VSS gf180mcu_fd_sc_mcu7t5v0__filltie
XFILLER_29_246 VDD VDD VSS VSS gf180mcu_fd_sc_mcu7t5v0__fill_1
XFILLER_45_717 VDD VDD VSS VSS gf180mcu_fd_sc_mcu7t5v0__fill_2
XFILLER_26_920 VDD VDD VSS VSS gf180mcu_fd_sc_mcu7t5v0__fillcap_8
XTAP_TAPCELL_ROW_84_1375 VDD VSS gf180mcu_fd_sc_mcu7t5v0__filltie
XFILLER_41_912 VDD VDD VSS VSS gf180mcu_fd_sc_mcu7t5v0__fillcap_16
XTAP_TAPCELL_ROW_51_951 VDD VSS gf180mcu_fd_sc_mcu7t5v0__filltie
XFILLER_126_527 VDD VDD VSS VSS gf180mcu_fd_sc_mcu7t5v0__fillcap_4
XFILLER_126_505 VDD VDD VSS VSS gf180mcu_fd_sc_mcu7t5v0__fillcap_16
XFILLER_120_2 VDD VDD VSS VSS gf180mcu_fd_sc_mcu7t5v0__fillcap_8
XFILLER_107_796 VDD VDD VSS VSS gf180mcu_fd_sc_mcu7t5v0__fill_2
XFILLER_79_113 VDD VDD VSS VSS gf180mcu_fd_sc_mcu7t5v0__fillcap_16
XFILLER_121_276 VDD VDD VSS VSS gf180mcu_fd_sc_mcu7t5v0__fillcap_4
XFILLER_57_50 VDD VDD VSS VSS gf180mcu_fd_sc_mcu7t5v0__fillcap_16
XFILLER_75_352 VDD VDD VSS VSS gf180mcu_fd_sc_mcu7t5v0__fillcap_16
XFILLER_36_717 VDD VDD VSS VSS gf180mcu_fd_sc_mcu7t5v0__fill_2
XFILLER_57_72 VDD VDD VSS VSS gf180mcu_fd_sc_mcu7t5v0__fillcap_16
XFILLER_17_931 VDD VDD VSS VSS gf180mcu_fd_sc_mcu7t5v0__fill_2
XFILLER_35_205 VDD VDD VSS VSS gf180mcu_fd_sc_mcu7t5v0__fillcap_4
XFILLER_90_333 VDD VDD VSS VSS gf180mcu_fd_sc_mcu7t5v0__fillcap_4
XFILLER_32_901 VDD VDD VSS VSS gf180mcu_fd_sc_mcu7t5v0__fill_2
XFILLER_63_558 VDD VDD VSS VSS gf180mcu_fd_sc_mcu7t5v0__fill_2
XFILLER_73_82 VDD VDD VSS VSS gf180mcu_fd_sc_mcu7t5v0__fill_1
XFILLER_31_422 VDD VDD VSS VSS gf180mcu_fd_sc_mcu7t5v0__fillcap_64
XFILLER_43_282 VDD VDD VSS VSS gf180mcu_fd_sc_mcu7t5v0__fill_1
X_2840_ place88/Z _3871_/Q _2850_/S _3871_/D VDD VDD VSS VSS gf180mcu_fd_sc_mcu7t5v0__mux2_2
XFILLER_117_516 VDD VDD VSS VSS gf180mcu_fd_sc_mcu7t5v0__fillcap_4
XFILLER_99_912 VDD VDD VSS VSS gf180mcu_fd_sc_mcu7t5v0__fillcap_16
XPHY_EDGE_ROW_9_Right_9 VDD VSS gf180mcu_fd_sc_mcu7t5v0__endcap
XFILLER_113_766 VDD VDD VSS VSS gf180mcu_fd_sc_mcu7t5v0__fillcap_4
XFILLER_101_906 VDD VDD VSS VSS gf180mcu_fd_sc_mcu7t5v0__fillcap_4
X_3323_ _3902_/Q _3323_/A2 _3370_/A1 VDD VDD VSS VSS gf180mcu_fd_sc_mcu7t5v0__nand2_1
XPHY_EDGE_ROW_107_Right_107 VDD VSS gf180mcu_fd_sc_mcu7t5v0__endcap
XPHY_EDGE_ROW_13_Left_146 VDD VSS gf180mcu_fd_sc_mcu7t5v0__endcap
X_3254_ _4078_/Q _3349_/A1 _3255_/B VDD VDD VSS VSS gf180mcu_fd_sc_mcu7t5v0__nor2_1
XFILLER_67_842 VDD VDD VSS VSS gf180mcu_fd_sc_mcu7t5v0__fillcap_64
X_3185_ _4032_/Q _4000_/Q _4129_/D _4032_/D VDD VDD VSS VSS gf180mcu_fd_sc_mcu7t5v0__mux2_2
XTAP_TAPCELL_ROW_1_304 VDD VSS gf180mcu_fd_sc_mcu7t5v0__filltie
XFILLER_27_706 VDD VDD VSS VSS gf180mcu_fd_sc_mcu7t5v0__fill_1
X_2136_ _2185_/A1 _2219_/B place68/I VDD VDD VSS VSS gf180mcu_fd_sc_mcu7t5v0__nor2_1
XFILLER_82_845 VDD VDD VSS VSS gf180mcu_fd_sc_mcu7t5v0__fillcap_16
X_2067_ _2008_/Z _2067_/A2 _2067_/B _4141_/D VDD VDD VSS VSS gf180mcu_fd_sc_mcu7t5v0__oai21_4
XFILLER_82_889 VDD VDD VSS VSS gf180mcu_fd_sc_mcu7t5v0__fill_2
XFILLER_81_344 VDD VDD VSS VSS gf180mcu_fd_sc_mcu7t5v0__fillcap_4
XTAP_TAPCELL_ROW_37_767 VDD VSS gf180mcu_fd_sc_mcu7t5v0__filltie
XFILLER_23_912 VDD VDD VSS VSS gf180mcu_fd_sc_mcu7t5v0__fillcap_16
XFILLER_35_772 VDD VDD VSS VSS gf180mcu_fd_sc_mcu7t5v0__fillcap_16
XFILLER_22_433 VDD VDD VSS VSS gf180mcu_fd_sc_mcu7t5v0__fillcap_4
XFILLER_50_731 VDD VDD VSS VSS gf180mcu_fd_sc_mcu7t5v0__fillcap_4
XPHY_EDGE_ROW_22_Left_155 VDD VSS gf180mcu_fd_sc_mcu7t5v0__endcap
XFILLER_50_786 VDD VDD VSS VSS gf180mcu_fd_sc_mcu7t5v0__fillcap_16
XFILLER_10_639 VDD VDD VSS VSS gf180mcu_fd_sc_mcu7t5v0__fill_1
XFILLER_5_109 VDD VDD VSS VSS gf180mcu_fd_sc_mcu7t5v0__fillcap_16
XFILLER_108_527 VDD VDD VSS VSS gf180mcu_fd_sc_mcu7t5v0__fillcap_64
XTAP_TAPCELL_ROW_9_404 VDD VSS gf180mcu_fd_sc_mcu7t5v0__filltie
XFILLER_104_711 VDD VDD VSS VSS gf180mcu_fd_sc_mcu7t5v0__fill_1
XFILLER_89_422 VDD VDD VSS VSS gf180mcu_fd_sc_mcu7t5v0__fillcap_64
XFILLER_78_27 VDD VDD VSS VSS gf180mcu_fd_sc_mcu7t5v0__fillcap_8
XPHY_EDGE_ROW_31_Left_164 VDD VSS gf180mcu_fd_sc_mcu7t5v0__endcap
XFILLER_104_799 VDD VDD VSS VSS gf180mcu_fd_sc_mcu7t5v0__fillcap_4
XTAP_TAPCELL_ROW_86_1404 VDD VSS gf180mcu_fd_sc_mcu7t5v0__filltie
XFILLER_27_20 VDD VDD VSS VSS gf180mcu_fd_sc_mcu7t5v0__fill_1
XFILLER_57_352 VDD VDD VSS VSS gf180mcu_fd_sc_mcu7t5v0__fillcap_16
XFILLER_84_171 VDD VDD VSS VSS gf180mcu_fd_sc_mcu7t5v0__fillcap_4
XFILLER_27_86 VDD VDD VSS VSS gf180mcu_fd_sc_mcu7t5v0__fill_1
XFILLER_14_923 VDD VDD VSS VSS gf180mcu_fd_sc_mcu7t5v0__fillcap_8
XPHY_EDGE_ROW_40_Left_173 VDD VSS gf180mcu_fd_sc_mcu7t5v0__endcap
XFILLER_13_422 VDD VDD VSS VSS gf180mcu_fd_sc_mcu7t5v0__fillcap_4
XFILLER_13_411 VDD VDD VSS VSS gf180mcu_fd_sc_mcu7t5v0__fillcap_8
XFILLER_25_282 VDD VDD VSS VSS gf180mcu_fd_sc_mcu7t5v0__fillcap_16
XFILLER_40_263 VDD VDD VSS VSS gf180mcu_fd_sc_mcu7t5v0__fillcap_4
XFILLER_40_285 VDD VDD VSS VSS gf180mcu_fd_sc_mcu7t5v0__fillcap_16
XTAP_TAPCELL_ROW_97_1544 VDD VSS gf180mcu_fd_sc_mcu7t5v0__filltie
XFILLER_122_574 VDD VDD VSS VSS gf180mcu_fd_sc_mcu7t5v0__fillcap_16
XFILLER_110_714 VDD VDD VSS VSS gf180mcu_fd_sc_mcu7t5v0__fillcap_4
XFILLER_49_842 VDD VDD VSS VSS gf180mcu_fd_sc_mcu7t5v0__fillcap_16
XFILLER_64_801 VDD VDD VSS VSS gf180mcu_fd_sc_mcu7t5v0__fillcap_4
XFILLER_63_322 VDD VDD VSS VSS gf180mcu_fd_sc_mcu7t5v0__fillcap_4
XTAP_TAPCELL_ROW_106_1662 VDD VSS gf180mcu_fd_sc_mcu7t5v0__filltie
XFILLER_90_174 VDD VDD VSS VSS gf180mcu_fd_sc_mcu7t5v0__fill_1
XFILLER_17_772 VDD VDD VSS VSS gf180mcu_fd_sc_mcu7t5v0__fillcap_8
XFILLER_51_506 VDD VDD VSS VSS gf180mcu_fd_sc_mcu7t5v0__fill_1
X_3941_ _3941_/D _4157_/RN _4092_/CLK _3941_/Q VDD VDD VSS VSS gf180mcu_fd_sc_mcu7t5v0__dffrnq_1
XFILLER_32_731 VDD VDD VSS VSS gf180mcu_fd_sc_mcu7t5v0__fillcap_4
XTAP_TAPCELL_ROW_34_726 VDD VSS gf180mcu_fd_sc_mcu7t5v0__filltie
XFILLER_44_591 VDD VDD VSS VSS gf180mcu_fd_sc_mcu7t5v0__fillcap_4
X_3872_ _3872_/D _4123_/CLK _3872_/Q VDD VDD VSS VSS gf180mcu_fd_sc_mcu7t5v0__dffq_1
XTAP_TAPCELL_ROW_14_472 VDD VSS gf180mcu_fd_sc_mcu7t5v0__filltie
X_2823_ place88/Z _3863_/Q _2833_/S _3863_/D VDD VDD VSS VSS gf180mcu_fd_sc_mcu7t5v0__mux2_2
X_2754_ _3831_/Q place88/Z _2764_/S _3831_/D VDD VDD VSS VSS gf180mcu_fd_sc_mcu7t5v0__mux2_2
XFILLER_129_195 VDD VDD VSS VSS gf180mcu_fd_sc_mcu7t5v0__fillcap_8
X_2685_ place87/Z _3800_/Q _2693_/S _3800_/D VDD VDD VSS VSS gf180mcu_fd_sc_mcu7t5v0__mux2_2
XTAP_TAPCELL_ROW_57_1027 VDD VSS gf180mcu_fd_sc_mcu7t5v0__filltie
XFILLER_98_241 VDD VDD VSS VSS gf180mcu_fd_sc_mcu7t5v0__fillcap_4
XFILLER_98_263 VDD VDD VSS VSS gf180mcu_fd_sc_mcu7t5v0__fillcap_8
XTAP_TAPCELL_ROW_130_1980 VDD VSS gf180mcu_fd_sc_mcu7t5v0__filltie
XFILLER_100_268 VDD VDD VSS VSS gf180mcu_fd_sc_mcu7t5v0__fill_1
X_3237_ _4057_/Q _3987_/Q _4129_/D _4057_/D VDD VDD VSS VSS gf180mcu_fd_sc_mcu7t5v0__mux2_2
XFILLER_39_330 VDD VDD VSS VSS gf180mcu_fd_sc_mcu7t5v0__fillcap_16
XFILLER_39_352 VDD VDD VSS VSS gf180mcu_fd_sc_mcu7t5v0__fillcap_64
XFILLER_55_812 VDD VDD VSS VSS gf180mcu_fd_sc_mcu7t5v0__fillcap_4
X_2119_ _2185_/A1 _4124_/D _2122_/A2 VDD VDD VSS VSS gf180mcu_fd_sc_mcu7t5v0__nand2_1
XFILLER_82_664 VDD VDD VSS VSS gf180mcu_fd_sc_mcu7t5v0__fill_1
XFILLER_54_333 VDD VDD VSS VSS gf180mcu_fd_sc_mcu7t5v0__fill_1
XFILLER_82_675 VDD VDD VSS VSS gf180mcu_fd_sc_mcu7t5v0__fillcap_4
XTAP_TAPCELL_ROW_68_1167 VDD VSS gf180mcu_fd_sc_mcu7t5v0__filltie
XTAP_TAPCELL_ROW_81_1334 VDD VSS gf180mcu_fd_sc_mcu7t5v0__filltie
XTAP_TAPCELL_ROW_81_1345 VDD VSS gf180mcu_fd_sc_mcu7t5v0__filltie
XFILLER_22_263 VDD VDD VSS VSS gf180mcu_fd_sc_mcu7t5v0__fill_1
XFILLER_22_296 VDD VDD VSS VSS gf180mcu_fd_sc_mcu7t5v0__fillcap_16
XFILLER_2_613 VDD VDD VSS VSS gf180mcu_fd_sc_mcu7t5v0__fillcap_8
XFILLER_132_883 VDD VDD VSS VSS gf180mcu_fd_sc_mcu7t5v0__fill_1
XFILLER_132_872 VDD VDD VSS VSS gf180mcu_fd_sc_mcu7t5v0__fill_2
XTAP_TAPCELL_ROW_92_1485 VDD VSS gf180mcu_fd_sc_mcu7t5v0__filltie
XFILLER_1_178 VDD VDD VSS VSS gf180mcu_fd_sc_mcu7t5v0__fill_2
XFILLER_58_661 VDD VDD VSS VSS gf180mcu_fd_sc_mcu7t5v0__fillcap_4
XFILLER_14_731 VDD VDD VSS VSS gf180mcu_fd_sc_mcu7t5v0__fillcap_4
XFILLER_60_314 VDD VDD VSS VSS gf180mcu_fd_sc_mcu7t5v0__fill_1
XFILLER_72_174 VDD VDD VSS VSS gf180mcu_fd_sc_mcu7t5v0__fill_1
XFILLER_60_369 VDD VDD VSS VSS gf180mcu_fd_sc_mcu7t5v0__fill_1
XFILLER_13_274 VDD VDD VSS VSS gf180mcu_fd_sc_mcu7t5v0__fillcap_4
XFILLER_9_212 VDD VDD VSS VSS gf180mcu_fd_sc_mcu7t5v0__fillcap_32
XTAP_TAPCELL_ROW_11_431 VDD VSS gf180mcu_fd_sc_mcu7t5v0__filltie
Xclkload26 _4146_/CLK clkload26/ZN VDD VDD VSS VSS gf180mcu_fd_sc_mcu7t5v0__clkinv_2
Xclkload15 _4112_/CLK clkload15/ZN VDD VDD VSS VSS gf180mcu_fd_sc_mcu7t5v0__inv_2
Xclkload48 _3978_/CLK clkload48/Z VDD VDD VSS VSS gf180mcu_fd_sc_mcu7t5v0__clkbuf_2
Xclkload37 _4109_/CLK clkload37/Z VDD VDD VSS VSS gf180mcu_fd_sc_mcu7t5v0__clkbuf_2
XFILLER_130_809 VDD VDD VSS VSS gf180mcu_fd_sc_mcu7t5v0__fill_1
X_4140_ _4140_/D _4148_/RN _4147_/CLK _4140_/Q VDD VDD VSS VSS gf180mcu_fd_sc_mcu7t5v0__dffrnq_1
XFILLER_96_734 VDD VDD VSS VSS gf180mcu_fd_sc_mcu7t5v0__fill_1
XFILLER_95_222 VDD VDD VSS VSS gf180mcu_fd_sc_mcu7t5v0__fill_1
X_4071_ _4071_/D _4157_/RN _4076_/CLK _4071_/Q VDD VDD VSS VSS gf180mcu_fd_sc_mcu7t5v0__dffrnq_1
XFILLER_95_277 VDD VDD VSS VSS gf180mcu_fd_sc_mcu7t5v0__fill_2
XTAP_TAPCELL_ROW_19_531 VDD VSS gf180mcu_fd_sc_mcu7t5v0__filltie
XFILLER_37_889 VDD VDD VSS VSS gf180mcu_fd_sc_mcu7t5v0__fillcap_16
XFILLER_52_815 VDD VDD VSS VSS gf180mcu_fd_sc_mcu7t5v0__fillcap_4
XFILLER_52_804 VDD VDD VSS VSS gf180mcu_fd_sc_mcu7t5v0__fill_1
XFILLER_52_837 VDD VDD VSS VSS gf180mcu_fd_sc_mcu7t5v0__fillcap_32
XFILLER_64_675 VDD VDD VSS VSS gf180mcu_fd_sc_mcu7t5v0__fillcap_4
XTAP_TAPCELL_ROW_47_895 VDD VSS gf180mcu_fd_sc_mcu7t5v0__filltie
XFILLER_51_325 VDD VDD VSS VSS gf180mcu_fd_sc_mcu7t5v0__fillcap_16
XFILLER_63_174 VDD VDD VSS VSS gf180mcu_fd_sc_mcu7t5v0__fillcap_16
X_3924_ _3924_/D _2279_/I _3981_/CLK _3924_/Q VDD VDD VSS VSS gf180mcu_fd_sc_mcu7t5v0__dffrnq_1
XFILLER_20_701 VDD VDD VSS VSS gf180mcu_fd_sc_mcu7t5v0__fillcap_16
X_3855_ _3855_/D _3865_/CLK _3855_/Q VDD VDD VSS VSS gf180mcu_fd_sc_mcu7t5v0__dffq_1
Xclkload9 clkload9/I clkload9/Z VDD VDD VSS VSS gf180mcu_fd_sc_mcu7t5v0__clkbuf_2
XTAP_TAPCELL_ROW_119_1831 VDD VSS gf180mcu_fd_sc_mcu7t5v0__filltie
X_2806_ place88/Z _3855_/Q _2816_/S _3855_/D VDD VDD VSS VSS gf180mcu_fd_sc_mcu7t5v0__mux2_2
X_3786_ _3786_/D clkload8/I _3786_/Q VDD VDD VSS VSS gf180mcu_fd_sc_mcu7t5v0__dffq_1
X_2668_ place87/Z _3792_/Q _2676_/S _3792_/D VDD VDD VSS VSS gf180mcu_fd_sc_mcu7t5v0__mux2_2
XFILLER_99_594 VDD VDD VSS VSS gf180mcu_fd_sc_mcu7t5v0__fill_1
XFILLER_59_414 VDD VDD VSS VSS gf180mcu_fd_sc_mcu7t5v0__fillcap_4
XFILLER_101_566 VDD VDD VSS VSS gf180mcu_fd_sc_mcu7t5v0__fill_2
XFILLER_131_34 VDD VDD VSS VSS gf180mcu_fd_sc_mcu7t5v0__fillcap_8
XFILLER_82_450 VDD VDD VSS VSS gf180mcu_fd_sc_mcu7t5v0__fillcap_4
XFILLER_15_517 VDD VDD VSS VSS gf180mcu_fd_sc_mcu7t5v0__fill_1
XFILLER_131_67 VDD VDD VSS VSS gf180mcu_fd_sc_mcu7t5v0__fill_2
XFILLER_42_325 VDD VDD VSS VSS gf180mcu_fd_sc_mcu7t5v0__fillcap_4
XFILLER_54_174 VDD VDD VSS VSS gf180mcu_fd_sc_mcu7t5v0__fill_1
XFILLER_70_667 VDD VDD VSS VSS gf180mcu_fd_sc_mcu7t5v0__fill_2
XFILLER_23_572 VDD VDD VSS VSS gf180mcu_fd_sc_mcu7t5v0__fillcap_4
XTAP_TAPCELL_ROW_94_1514 VDD VSS gf180mcu_fd_sc_mcu7t5v0__filltie
XTAP_TAPCELL_ROW_94_1503 VDD VSS gf180mcu_fd_sc_mcu7t5v0__filltie
XFILLER_2_454 VDD VDD VSS VSS gf180mcu_fd_sc_mcu7t5v0__fill_1
XFILLER_104_382 VDD VDD VSS VSS gf180mcu_fd_sc_mcu7t5v0__fill_2
XFILLER_49_40 VDD VDD VSS VSS gf180mcu_fd_sc_mcu7t5v0__fill_1
XFILLER_77_244 VDD VDD VSS VSS gf180mcu_fd_sc_mcu7t5v0__fillcap_8
XFILLER_77_277 VDD VDD VSS VSS gf180mcu_fd_sc_mcu7t5v0__fill_2
XFILLER_37_119 VDD VDD VSS VSS gf180mcu_fd_sc_mcu7t5v0__fillcap_16
XFILLER_92_247 VDD VDD VSS VSS gf180mcu_fd_sc_mcu7t5v0__fillcap_16
XFILLER_18_333 VDD VDD VSS VSS gf180mcu_fd_sc_mcu7t5v0__fillcap_8
XFILLER_18_311 VDD VDD VSS VSS gf180mcu_fd_sc_mcu7t5v0__fillcap_4
XFILLER_46_675 VDD VDD VSS VSS gf180mcu_fd_sc_mcu7t5v0__fillcap_4
XFILLER_65_72 VDD VDD VSS VSS gf180mcu_fd_sc_mcu7t5v0__fillcap_32
XFILLER_34_859 VDD VDD VSS VSS gf180mcu_fd_sc_mcu7t5v0__fill_1
XFILLER_60_122 VDD VDD VSS VSS gf180mcu_fd_sc_mcu7t5v0__fillcap_16
XTAP_TAPCELL_ROW_103_1621 VDD VSS gf180mcu_fd_sc_mcu7t5v0__filltie
XTAP_TAPCELL_ROW_44_854 VDD VSS gf180mcu_fd_sc_mcu7t5v0__filltie
XFILLER_60_177 VDD VDD VSS VSS gf180mcu_fd_sc_mcu7t5v0__fillcap_32
XFILLER_61_689 VDD VDD VSS VSS gf180mcu_fd_sc_mcu7t5v0__fillcap_8
XFILLER_14_594 VDD VDD VSS VSS gf180mcu_fd_sc_mcu7t5v0__fill_1
X_3640_ _3640_/D _4114_/CLK _3640_/Q VDD VDD VSS VSS gf180mcu_fd_sc_mcu7t5v0__dffq_1
XTAP_TAPCELL_ROW_132_2017 VDD VSS gf180mcu_fd_sc_mcu7t5v0__filltie
XTAP_TAPCELL_ROW_132_2006 VDD VSS gf180mcu_fd_sc_mcu7t5v0__filltie
X_3571_ _3567_/Z _3568_/Z _3569_/Z _3570_/Z place74/Z _4119_/Q _3571_/Z VDD VDD VSS
+ VSS gf180mcu_fd_sc_mcu7t5v0__mux4_1
XTAP_TAPCELL_ROW_114_1772 VDD VSS gf180mcu_fd_sc_mcu7t5v0__filltie
XFILLER_46_2 VDD VDD VSS VSS gf180mcu_fd_sc_mcu7t5v0__fillcap_8
XFILLER_130_628 VDD VDD VSS VSS gf180mcu_fd_sc_mcu7t5v0__fillcap_16
XFILLER_69_745 VDD VDD VSS VSS gf180mcu_fd_sc_mcu7t5v0__fillcap_16
XFILLER_111_842 VDD VDD VSS VSS gf180mcu_fd_sc_mcu7t5v0__fillcap_32
X_4123_ _4123_/D _4157_/RN _4123_/CLK _4123_/Q VDD VDD VSS VSS gf180mcu_fd_sc_mcu7t5v0__dffrnq_1
XFILLER_96_597 VDD VDD VSS VSS gf180mcu_fd_sc_mcu7t5v0__fillcap_64
XFILLER_96_575 VDD VDD VSS VSS gf180mcu_fd_sc_mcu7t5v0__fillcap_8
X_4054_ _4054_/D input92/Z _4129_/CLK _4054_/Q VDD VDD VSS VSS gf180mcu_fd_sc_mcu7t5v0__dffrnq_1
XFILLER_25_804 VDD VDD VSS VSS gf180mcu_fd_sc_mcu7t5v0__fill_2
XTAP_TAPCELL_ROW_65_1126 VDD VSS gf180mcu_fd_sc_mcu7t5v0__filltie
XTAP_TAPCELL_ROW_65_1137 VDD VSS gf180mcu_fd_sc_mcu7t5v0__filltie
XFILLER_40_807 VDD VDD VSS VSS gf180mcu_fd_sc_mcu7t5v0__fillcap_64
XFILLER_52_667 VDD VDD VSS VSS gf180mcu_fd_sc_mcu7t5v0__fillcap_16
X_3907_ _3907_/D _2279_/I _4114_/CLK _3907_/Q VDD VDD VSS VSS gf180mcu_fd_sc_mcu7t5v0__dffrnq_1
X_3838_ _3838_/D _3866_/CLK _3838_/Q VDD VDD VSS VSS gf180mcu_fd_sc_mcu7t5v0__dffq_1
XFILLER_118_430 VDD VDD VSS VSS gf180mcu_fd_sc_mcu7t5v0__fillcap_4
XFILLER_20_597 VDD VDD VSS VSS gf180mcu_fd_sc_mcu7t5v0__fillcap_16
XFILLER_118_452 VDD VDD VSS VSS gf180mcu_fd_sc_mcu7t5v0__fill_2
X_3769_ _3769_/D _3877_/CLK _3769_/Q VDD VDD VSS VSS gf180mcu_fd_sc_mcu7t5v0__dffq_1
XFILLER_126_23 VDD VDD VSS VSS gf180mcu_fd_sc_mcu7t5v0__fillcap_8
XTAP_TAPCELL_ROW_76_1277 VDD VSS gf180mcu_fd_sc_mcu7t5v0__filltie
XPHY_EDGE_ROW_5_Left_138 VDD VSS gf180mcu_fd_sc_mcu7t5v0__endcap
XFILLER_121_628 VDD VDD VSS VSS gf180mcu_fd_sc_mcu7t5v0__fill_2
XFILLER_86_27 VDD VDD VSS VSS gf180mcu_fd_sc_mcu7t5v0__fillcap_8
XFILLER_101_341 VDD VDD VSS VSS gf180mcu_fd_sc_mcu7t5v0__fillcap_8
XFILLER_87_542 VDD VDD VSS VSS gf180mcu_fd_sc_mcu7t5v0__fillcap_16
XFILLER_101_352 VDD VDD VSS VSS gf180mcu_fd_sc_mcu7t5v0__fillcap_64
XFILLER_19_65 VDD VDD VSS VSS gf180mcu_fd_sc_mcu7t5v0__fillcap_4
XFILLER_19_108 VDD VDD VSS VSS gf180mcu_fd_sc_mcu7t5v0__fill_1
XFILLER_74_247 VDD VDD VSS VSS gf180mcu_fd_sc_mcu7t5v0__fillcap_16
XFILLER_16_815 VDD VDD VSS VSS gf180mcu_fd_sc_mcu7t5v0__fillcap_4
XFILLER_28_664 VDD VDD VSS VSS gf180mcu_fd_sc_mcu7t5v0__fill_1
XFILLER_71_932 VDD VDD VSS VSS gf180mcu_fd_sc_mcu7t5v0__fill_2
XFILLER_55_472 VDD VDD VSS VSS gf180mcu_fd_sc_mcu7t5v0__fillcap_16
XFILLER_43_656 VDD VDD VSS VSS gf180mcu_fd_sc_mcu7t5v0__fillcap_4
XFILLER_24_892 VDD VDD VSS VSS gf180mcu_fd_sc_mcu7t5v0__fillcap_4
XFILLER_30_317 VDD VDD VSS VSS gf180mcu_fd_sc_mcu7t5v0__fillcap_16
XTAP_TAPCELL_ROW_41_813 VDD VSS gf180mcu_fd_sc_mcu7t5v0__filltie
XTAP_TAPCELL_ROW_41_824 VDD VSS gf180mcu_fd_sc_mcu7t5v0__filltie
XFILLER_42_177 VDD VDD VSS VSS gf180mcu_fd_sc_mcu7t5v0__fillcap_16
XFILLER_7_524 VDD VDD VSS VSS gf180mcu_fd_sc_mcu7t5v0__fillcap_16
XFILLER_125_912 VDD VDD VSS VSS gf180mcu_fd_sc_mcu7t5v0__fillcap_16
XFILLER_98_807 VDD VDD VSS VSS gf180mcu_fd_sc_mcu7t5v0__fillcap_4
XFILLER_105_691 VDD VDD VSS VSS gf180mcu_fd_sc_mcu7t5v0__fillcap_8
XFILLER_78_542 VDD VDD VSS VSS gf180mcu_fd_sc_mcu7t5v0__fillcap_32
XFILLER_78_597 VDD VDD VSS VSS gf180mcu_fd_sc_mcu7t5v0__fillcap_64
XTAP_TAPCELL_ROW_49_924 VDD VSS gf180mcu_fd_sc_mcu7t5v0__filltie
XFILLER_66_737 VDD VDD VSS VSS gf180mcu_fd_sc_mcu7t5v0__fillcap_64
XFILLER_93_556 VDD VDD VSS VSS gf180mcu_fd_sc_mcu7t5v0__fillcap_4
XFILLER_38_439 VDD VDD VSS VSS gf180mcu_fd_sc_mcu7t5v0__fill_1
XFILLER_18_174 VDD VDD VSS VSS gf180mcu_fd_sc_mcu7t5v0__fill_1
Xplace81 _4070_/Q place81/Z VDD VDD VSS VSS gf180mcu_fd_sc_mcu7t5v0__buf_8
XFILLER_19_697 VDD VDD VSS VSS gf180mcu_fd_sc_mcu7t5v0__fill_2
Xplace70 place70/I _4131_/D VDD VDD VSS VSS gf180mcu_fd_sc_mcu7t5v0__buf_8
XFILLER_22_807 VDD VDD VSS VSS gf180mcu_fd_sc_mcu7t5v0__fillcap_8
XFILLER_34_667 VDD VDD VSS VSS gf180mcu_fd_sc_mcu7t5v0__fillcap_64
XFILLER_15_870 VDD VDD VSS VSS gf180mcu_fd_sc_mcu7t5v0__fill_2
X_1953_ _4148_/Q _4084_/Q _1952_/Z _1953_/Z VDD VDD VSS VSS gf180mcu_fd_sc_mcu7t5v0__and3_1
X_1884_ _1884_/A1 _1884_/A2 _1884_/B _1884_/C _1915_/A1 VDD VDD VSS VSS gf180mcu_fd_sc_mcu7t5v0__aoi211_1
XFILLER_30_873 VDD VDD VSS VSS gf180mcu_fd_sc_mcu7t5v0__fill_2
XTAP_TAPCELL_ROW_60_1067 VDD VSS gf180mcu_fd_sc_mcu7t5v0__filltie
X_3623_ _3626_/A1 _4064_/Q _3623_/A3 _3624_/S VDD VDD VSS VSS gf180mcu_fd_sc_mcu7t5v0__nand3_1
XFILLER_128_772 VDD VDD VSS VSS gf180mcu_fd_sc_mcu7t5v0__fill_2
XFILLER_127_282 VDD VDD VSS VSS gf180mcu_fd_sc_mcu7t5v0__fillcap_16
XFILLER_115_422 VDD VDD VSS VSS gf180mcu_fd_sc_mcu7t5v0__fillcap_8
X_3554_ _3838_/Q _3846_/Q _3854_/Q _3862_/Q place76/Z place75/Z _3554_/Z VDD VDD VSS
+ VSS gf180mcu_fd_sc_mcu7t5v0__mux4_1
XFILLER_89_818 VDD VDD VSS VSS gf180mcu_fd_sc_mcu7t5v0__fillcap_16
X_2505_ _2505_/A1 _2505_/A2 place56/I VDD VDD VSS VSS gf180mcu_fd_sc_mcu7t5v0__nor2_1
X_3485_ _3485_/A1 _3484_/Z _3485_/B _3496_/A2 VDD VDD VSS VSS gf180mcu_fd_sc_mcu7t5v0__aoi21_1
XFILLER_130_403 VDD VDD VSS VSS gf180mcu_fd_sc_mcu7t5v0__fill_1
XFILLER_88_317 VDD VDD VSS VSS gf180mcu_fd_sc_mcu7t5v0__fillcap_8
X_2436_ _3694_/Q _4068_/Q _2448_/S _3694_/D VDD VDD VSS VSS gf180mcu_fd_sc_mcu7t5v0__mux2_2
X_2367_ _3663_/Q _4069_/Q _2377_/S _3663_/D VDD VDD VSS VSS gf180mcu_fd_sc_mcu7t5v0__mux2_2
XFILLER_84_534 VDD VDD VSS VSS gf180mcu_fd_sc_mcu7t5v0__fill_1
X_2298_ _3636_/Q _4074_/Q _2298_/S _3636_/D VDD VDD VSS VSS gf180mcu_fd_sc_mcu7t5v0__mux2_2
X_4106_ _4106_/D _4157_/RN _4157_/CLK _4106_/Q VDD VDD VSS VSS gf180mcu_fd_sc_mcu7t5v0__dffrnq_1
XFILLER_56_247 VDD VDD VSS VSS gf180mcu_fd_sc_mcu7t5v0__fillcap_64
X_4037_ _4037_/D _4148_/RN _4146_/CLK _4037_/Q VDD VDD VSS VSS gf180mcu_fd_sc_mcu7t5v0__dffrnq_1
XTAP_TAPCELL_ROW_127_1941 VDD VSS gf180mcu_fd_sc_mcu7t5v0__filltie
XFILLER_52_442 VDD VDD VSS VSS gf180mcu_fd_sc_mcu7t5v0__fill_2
XFILLER_12_317 VDD VDD VSS VSS gf180mcu_fd_sc_mcu7t5v0__fillcap_16
XFILLER_24_155 VDD VDD VSS VSS gf180mcu_fd_sc_mcu7t5v0__fillcap_16
XFILLER_24_177 VDD VDD VSS VSS gf180mcu_fd_sc_mcu7t5v0__fillcap_64
XTAP_TAPCELL_ROW_78_1306 VDD VSS gf180mcu_fd_sc_mcu7t5v0__filltie
XFILLER_119_772 VDD VDD VSS VSS gf180mcu_fd_sc_mcu7t5v0__fillcap_8
XFILLER_107_912 VDD VDD VSS VSS gf180mcu_fd_sc_mcu7t5v0__fillcap_16
XFILLER_4_505 VDD VDD VSS VSS gf180mcu_fd_sc_mcu7t5v0__fillcap_16
XFILLER_4_527 VDD VDD VSS VSS gf180mcu_fd_sc_mcu7t5v0__fillcap_4
XFILLER_122_926 VDD VDD VSS VSS gf180mcu_fd_sc_mcu7t5v0__fillcap_8
Xoutput180 _4130_/Q s_axi_wready VDD VDD VSS VSS gf180mcu_fd_sc_mcu7t5v0__dlyb_1
XFILLER_102_683 VDD VDD VSS VSS gf180mcu_fd_sc_mcu7t5v0__fill_2
XFILLER_88_873 VDD VDD VSS VSS gf180mcu_fd_sc_mcu7t5v0__fill_2
XTAP_TAPCELL_ROW_7_376 VDD VSS gf180mcu_fd_sc_mcu7t5v0__filltie
XFILLER_48_737 VDD VDD VSS VSS gf180mcu_fd_sc_mcu7t5v0__fillcap_64
XFILLER_101_182 VDD VDD VSS VSS gf180mcu_fd_sc_mcu7t5v0__fillcap_16
XTAP_TAPCELL_ROW_89_1446 VDD VSS gf180mcu_fd_sc_mcu7t5v0__filltie
XFILLER_75_556 VDD VDD VSS VSS gf180mcu_fd_sc_mcu7t5v0__fillcap_4
XFILLER_90_559 VDD VDD VSS VSS gf180mcu_fd_sc_mcu7t5v0__fillcap_8
XFILLER_71_762 VDD VDD VSS VSS gf180mcu_fd_sc_mcu7t5v0__fillcap_8
XFILLER_16_667 VDD VDD VSS VSS gf180mcu_fd_sc_mcu7t5v0__fillcap_16
XFILLER_15_166 VDD VDD VSS VSS gf180mcu_fd_sc_mcu7t5v0__fillcap_4
XFILLER_43_486 VDD VDD VSS VSS gf180mcu_fd_sc_mcu7t5v0__fillcap_4
XTAP_TAPCELL_ROW_54_982 VDD VSS gf180mcu_fd_sc_mcu7t5v0__filltie
XFILLER_31_648 VDD VDD VSS VSS gf180mcu_fd_sc_mcu7t5v0__fillcap_8
XTAP_TAPCELL_ROW_54_993 VDD VSS gf180mcu_fd_sc_mcu7t5v0__filltie
XFILLER_129_525 VDD VDD VSS VSS gf180mcu_fd_sc_mcu7t5v0__fill_2
XFILLER_129_514 VDD VDD VSS VSS gf180mcu_fd_sc_mcu7t5v0__fill_1
XFILLER_12_851 VDD VDD VSS VSS gf180mcu_fd_sc_mcu7t5v0__fillcap_16
XFILLER_62_95 VDD VDD VSS VSS gf180mcu_fd_sc_mcu7t5v0__fillcap_8
XFILLER_116_219 VDD VDD VSS VSS gf180mcu_fd_sc_mcu7t5v0__fillcap_16
XFILLER_8_877 VDD VDD VSS VSS gf180mcu_fd_sc_mcu7t5v0__fillcap_32
XFILLER_109_271 VDD VDD VSS VSS gf180mcu_fd_sc_mcu7t5v0__fillcap_8
XTAP_TAPCELL_ROW_111_1731 VDD VSS gf180mcu_fd_sc_mcu7t5v0__filltie
X_3270_ _3256_/Z _3270_/A2 _3271_/B1 VDD VDD VSS VSS gf180mcu_fd_sc_mcu7t5v0__nor2_1
XFILLER_112_447 VDD VDD VSS VSS gf180mcu_fd_sc_mcu7t5v0__fillcap_8
XFILLER_97_158 VDD VDD VSS VSS gf180mcu_fd_sc_mcu7t5v0__fillcap_4
X_2152_ _4112_/Q _3935_/Q _2152_/S _2152_/Z VDD VDD VSS VSS gf180mcu_fd_sc_mcu7t5v0__mux2_2
X_2083_ _2008_/Z _2083_/A2 _2083_/B _4144_/D VDD VDD VSS VSS gf180mcu_fd_sc_mcu7t5v0__oai21_4
XFILLER_38_247 VDD VDD VSS VSS gf180mcu_fd_sc_mcu7t5v0__fillcap_32
XFILLER_66_589 VDD VDD VSS VSS gf180mcu_fd_sc_mcu7t5v0__fillcap_4
XTAP_TAPCELL_ROW_122_1871 VDD VSS gf180mcu_fd_sc_mcu7t5v0__filltie
XFILLER_22_637 VDD VDD VSS VSS gf180mcu_fd_sc_mcu7t5v0__fillcap_4
X_2985_ _3937_/Q _4025_/Q _3041_/S _3937_/D VDD VDD VSS VSS gf180mcu_fd_sc_mcu7t5v0__mux2_2
X_1936_ _4147_/Q _2905_/A1 _4146_/Q _1935_/Z _1938_/A2 VDD VDD VSS VSS gf180mcu_fd_sc_mcu7t5v0__aoi22_1
XPHY_EDGE_ROW_86_Left_219 VDD VSS gf180mcu_fd_sc_mcu7t5v0__endcap
XTAP_TAPCELL_ROW_32_698 VDD VSS gf180mcu_fd_sc_mcu7t5v0__filltie
X_1867_ _3888_/Q _2881_/A1 VDD VDD VSS VSS gf180mcu_fd_sc_mcu7t5v0__clkinv_1
X_1798_ _4114_/Q _1797_/Z _4124_/D VDD VDD VSS VSS gf180mcu_fd_sc_mcu7t5v0__nor2_1
Xinput93 s_axi_araddr[0] input93/Z VDD VDD VSS VSS gf180mcu_fd_sc_mcu7t5v0__dlyb_1
X_3537_ _3537_/A1 _3537_/A2 _4121_/D VDD VDD VSS VSS gf180mcu_fd_sc_mcu7t5v0__xor2_1
XFILLER_131_723 VDD VDD VSS VSS gf180mcu_fd_sc_mcu7t5v0__fillcap_8
XFILLER_107_36 VDD VDD VSS VSS gf180mcu_fd_sc_mcu7t5v0__fill_1
XFILLER_89_626 VDD VDD VSS VSS gf180mcu_fd_sc_mcu7t5v0__fillcap_4
XTAP_TAPCELL_ROW_73_1236 VDD VSS gf180mcu_fd_sc_mcu7t5v0__filltie
XFILLER_130_244 VDD VDD VSS VSS gf180mcu_fd_sc_mcu7t5v0__fill_1
XFILLER_107_69 VDD VDD VSS VSS gf180mcu_fd_sc_mcu7t5v0__fill_1
X_3468_ _3901_/Q _3468_/A2 _3474_/A1 VDD VDD VSS VSS gf180mcu_fd_sc_mcu7t5v0__nand2_1
X_3399_ place78/Z _3399_/A2 _4092_/D VDD VDD VSS VSS gf180mcu_fd_sc_mcu7t5v0__xnor2_1
XPHY_EDGE_ROW_95_Left_228 VDD VSS gf180mcu_fd_sc_mcu7t5v0__endcap
XTAP_TAPCELL_ROW_4_335 VDD VSS gf180mcu_fd_sc_mcu7t5v0__filltie
XFILLER_29_214 VDD VDD VSS VSS gf180mcu_fd_sc_mcu7t5v0__fill_1
XFILLER_57_534 VDD VDD VSS VSS gf180mcu_fd_sc_mcu7t5v0__fill_1
XFILLER_26_932 VDD VDD VSS VSS gf180mcu_fd_sc_mcu7t5v0__fill_2
XFILLER_44_239 VDD VDD VSS VSS gf180mcu_fd_sc_mcu7t5v0__fillcap_4
XTAP_TAPCELL_ROW_84_1376 VDD VSS gf180mcu_fd_sc_mcu7t5v0__filltie
XFILLER_13_626 VDD VDD VSS VSS gf180mcu_fd_sc_mcu7t5v0__fillcap_4
XFILLER_25_486 VDD VDD VSS VSS gf180mcu_fd_sc_mcu7t5v0__fillcap_4
XFILLER_12_158 VDD VDD VSS VSS gf180mcu_fd_sc_mcu7t5v0__fillcap_16
XFILLER_8_107 VDD VDD VSS VSS gf180mcu_fd_sc_mcu7t5v0__fillcap_64
XTAP_TAPCELL_ROW_51_952 VDD VSS gf180mcu_fd_sc_mcu7t5v0__filltie
XFILLER_5_836 VDD VDD VSS VSS gf180mcu_fd_sc_mcu7t5v0__fillcap_4
XFILLER_4_346 VDD VDD VSS VSS gf180mcu_fd_sc_mcu7t5v0__fillcap_4
XFILLER_106_263 VDD VDD VSS VSS gf180mcu_fd_sc_mcu7t5v0__fillcap_8
XFILLER_94_139 VDD VDD VSS VSS gf180mcu_fd_sc_mcu7t5v0__fillcap_8
XFILLER_76_843 VDD VDD VSS VSS gf180mcu_fd_sc_mcu7t5v0__fill_2
XFILLER_87_191 VDD VDD VSS VSS gf180mcu_fd_sc_mcu7t5v0__fillcap_16
XFILLER_75_342 VDD VDD VSS VSS gf180mcu_fd_sc_mcu7t5v0__fill_1
XFILLER_35_228 VDD VDD VSS VSS gf180mcu_fd_sc_mcu7t5v0__fill_2
XFILLER_90_378 VDD VDD VSS VSS gf180mcu_fd_sc_mcu7t5v0__fillcap_4
XFILLER_73_72 VDD VDD VSS VSS gf180mcu_fd_sc_mcu7t5v0__fillcap_8
XFILLER_71_570 VDD VDD VSS VSS gf180mcu_fd_sc_mcu7t5v0__fillcap_4
X_2770_ place89/Z _3838_/Q _2782_/S _3838_/D VDD VDD VSS VSS gf180mcu_fd_sc_mcu7t5v0__mux2_2
XFILLER_132_509 VDD VDD VSS VSS gf180mcu_fd_sc_mcu7t5v0__fill_1
X_3322_ _3322_/A1 _3316_/Z _3335_/B _3326_/A2 VDD VDD VSS VSS gf180mcu_fd_sc_mcu7t5v0__oai21_1
XFILLER_112_255 VDD VDD VSS VSS gf180mcu_fd_sc_mcu7t5v0__fillcap_4
X_3253_ _3349_/A1 _3278_/A1 _3278_/A2 _3253_/Z VDD VDD VSS VSS gf180mcu_fd_sc_mcu7t5v0__and3_1
XFILLER_112_299 VDD VDD VSS VSS gf180mcu_fd_sc_mcu7t5v0__fillcap_16
X_2204_ _3375_/A2 _2203_/Z _2208_/A1 VDD VDD VSS VSS gf180mcu_fd_sc_mcu7t5v0__nand2_1
XFILLER_82_802 VDD VDD VSS VSS gf180mcu_fd_sc_mcu7t5v0__fill_2
XTAP_TAPCELL_ROW_1_305 VDD VSS gf180mcu_fd_sc_mcu7t5v0__filltie
XTAP_TAPCELL_ROW_124_1900 VDD VSS gf180mcu_fd_sc_mcu7t5v0__filltie
XFILLER_93_150 VDD VDD VSS VSS gf180mcu_fd_sc_mcu7t5v0__fillcap_4
X_2066_ place71/Z place52/Z _2064_/Z _2067_/B VDD VDD VSS VSS gf180mcu_fd_sc_mcu7t5v0__nand3_1
XFILLER_26_239 VDD VDD VSS VSS gf180mcu_fd_sc_mcu7t5v0__fillcap_4
XFILLER_54_559 VDD VDD VSS VSS gf180mcu_fd_sc_mcu7t5v0__fillcap_16
XTAP_TAPCELL_ROW_37_768 VDD VSS gf180mcu_fd_sc_mcu7t5v0__filltie
XFILLER_41_209 VDD VDD VSS VSS gf180mcu_fd_sc_mcu7t5v0__fill_1
XFILLER_50_754 VDD VDD VSS VSS gf180mcu_fd_sc_mcu7t5v0__fillcap_32
X_2968_ _4050_/Q _3930_/Q _2972_/S _3930_/D VDD VDD VSS VSS gf180mcu_fd_sc_mcu7t5v0__mux2_2
XFILLER_10_629 VDD VDD VSS VSS gf180mcu_fd_sc_mcu7t5v0__fillcap_8
X_1919_ _1855_/B _2068_/A1 _1919_/B _1919_/C _1931_/A2 VDD VDD VSS VSS gf180mcu_fd_sc_mcu7t5v0__oai211_1
X_2899_ _2899_/A1 _2900_/S _2899_/B _3897_/D VDD VDD VSS VSS gf180mcu_fd_sc_mcu7t5v0__oai21_1
XFILLER_118_57 VDD VDD VSS VSS gf180mcu_fd_sc_mcu7t5v0__fill_2
XTAP_TAPCELL_ROW_9_405 VDD VSS gf180mcu_fd_sc_mcu7t5v0__filltie
XFILLER_131_531 VDD VDD VSS VSS gf180mcu_fd_sc_mcu7t5v0__fillcap_8
XFILLER_104_745 VDD VDD VSS VSS gf180mcu_fd_sc_mcu7t5v0__fillcap_4
XFILLER_1_349 VDD VDD VSS VSS gf180mcu_fd_sc_mcu7t5v0__fill_1
XFILLER_77_629 VDD VDD VSS VSS gf180mcu_fd_sc_mcu7t5v0__fill_1
XFILLER_77_607 VDD VDD VSS VSS gf180mcu_fd_sc_mcu7t5v0__fillcap_16
XFILLER_94_27 VDD VDD VSS VSS gf180mcu_fd_sc_mcu7t5v0__fillcap_8
XFILLER_69_191 VDD VDD VSS VSS gf180mcu_fd_sc_mcu7t5v0__fillcap_16
XTAP_TAPCELL_ROW_86_1405 VDD VSS gf180mcu_fd_sc_mcu7t5v0__filltie
XFILLER_85_695 VDD VDD VSS VSS gf180mcu_fd_sc_mcu7t5v0__fillcap_4
XFILLER_17_206 VDD VDD VSS VSS gf180mcu_fd_sc_mcu7t5v0__fillcap_4
XFILLER_45_504 VDD VDD VSS VSS gf180mcu_fd_sc_mcu7t5v0__fill_2
XFILLER_45_559 VDD VDD VSS VSS gf180mcu_fd_sc_mcu7t5v0__fill_1
XFILLER_60_518 VDD VDD VSS VSS gf180mcu_fd_sc_mcu7t5v0__fillcap_4
XFILLER_9_416 VDD VDD VSS VSS gf180mcu_fd_sc_mcu7t5v0__fillcap_4
XTAP_TAPCELL_ROW_97_1545 VDD VSS gf180mcu_fd_sc_mcu7t5v0__filltie
XFILLER_99_209 VDD VDD VSS VSS gf180mcu_fd_sc_mcu7t5v0__fill_1
XFILLER_5_699 VDD VDD VSS VSS gf180mcu_fd_sc_mcu7t5v0__fill_1
XFILLER_4_58 VDD VDD VSS VSS gf180mcu_fd_sc_mcu7t5v0__fillcap_8
XFILLER_122_564 VDD VDD VSS VSS gf180mcu_fd_sc_mcu7t5v0__fillcap_4
XFILLER_68_629 VDD VDD VSS VSS gf180mcu_fd_sc_mcu7t5v0__fillcap_4
XFILLER_122_597 VDD VDD VSS VSS gf180mcu_fd_sc_mcu7t5v0__fillcap_32
XFILLER_110_737 VDD VDD VSS VSS gf180mcu_fd_sc_mcu7t5v0__fillcap_64
XFILLER_67_139 VDD VDD VSS VSS gf180mcu_fd_sc_mcu7t5v0__fill_1
XFILLER_91_632 VDD VDD VSS VSS gf180mcu_fd_sc_mcu7t5v0__fillcap_8
XTAP_TAPCELL_ROW_106_1663 VDD VSS gf180mcu_fd_sc_mcu7t5v0__filltie
X_3940_ _3940_/D _2279_/I _4126_/CLK _3940_/Q VDD VDD VSS VSS gf180mcu_fd_sc_mcu7t5v0__dffrnq_1
XTAP_TAPCELL_ROW_34_727 VDD VSS gf180mcu_fd_sc_mcu7t5v0__filltie
X_3871_ _3871_/D _4148_/CLK _3871_/Q VDD VDD VSS VSS gf180mcu_fd_sc_mcu7t5v0__dffq_1
XTAP_TAPCELL_ROW_14_473 VDD VSS gf180mcu_fd_sc_mcu7t5v0__filltie
XTAP_TAPCELL_ROW_14_462 VDD VSS gf180mcu_fd_sc_mcu7t5v0__filltie
XFILLER_129_163 VDD VDD VSS VSS gf180mcu_fd_sc_mcu7t5v0__fillcap_32
XFILLER_118_837 VDD VDD VSS VSS gf180mcu_fd_sc_mcu7t5v0__fillcap_4
XFILLER_99_710 VDD VDD VSS VSS gf180mcu_fd_sc_mcu7t5v0__fillcap_4
XTAP_TAPCELL_ROW_57_1028 VDD VSS gf180mcu_fd_sc_mcu7t5v0__filltie
XFILLER_125_380 VDD VDD VSS VSS gf180mcu_fd_sc_mcu7t5v0__fill_1
XFILLER_113_542 VDD VDD VSS VSS gf180mcu_fd_sc_mcu7t5v0__fill_2
XTAP_TAPCELL_ROW_130_1970 VDD VSS gf180mcu_fd_sc_mcu7t5v0__filltie
XFILLER_99_787 VDD VDD VSS VSS gf180mcu_fd_sc_mcu7t5v0__fill_2
X_3305_ _4071_/Q _4165_/Q _4157_/D _4071_/D VDD VDD VSS VSS gf180mcu_fd_sc_mcu7t5v0__mux2_2
XTAP_TAPCELL_ROW_130_1981 VDD VSS gf180mcu_fd_sc_mcu7t5v0__filltie
X_3236_ _3519_/A1 _4129_/D _3236_/B _4056_/D VDD VDD VSS VSS gf180mcu_fd_sc_mcu7t5v0__oai21_1
XFILLER_73_109 VDD VDD VSS VSS gf180mcu_fd_sc_mcu7t5v0__fillcap_16
XFILLER_54_312 VDD VDD VSS VSS gf180mcu_fd_sc_mcu7t5v0__fill_2
X_3167_ place88/Z _3991_/Q _4129_/D _4023_/D VDD VDD VSS VSS gf180mcu_fd_sc_mcu7t5v0__mux2_2
X_2118_ _2112_/I _3885_/Q _2122_/A1 VDD VDD VSS VSS gf180mcu_fd_sc_mcu7t5v0__nand2_1
XFILLER_27_559 VDD VDD VSS VSS gf180mcu_fd_sc_mcu7t5v0__fill_1
X_3098_ _3990_/Q _3098_/I1 _3160_/S _3990_/D VDD VDD VSS VSS gf180mcu_fd_sc_mcu7t5v0__mux2_2
X_2049_ place71/Z place52/Z _2047_/Z _2050_/B VDD VDD VSS VSS gf180mcu_fd_sc_mcu7t5v0__nand3_1
XFILLER_81_142 VDD VDD VSS VSS gf180mcu_fd_sc_mcu7t5v0__fillcap_64
XFILLER_14_209 VDD VDD VSS VSS gf180mcu_fd_sc_mcu7t5v0__fill_1
XTAP_TAPCELL_ROW_68_1168 VDD VSS gf180mcu_fd_sc_mcu7t5v0__filltie
XFILLER_35_581 VDD VDD VSS VSS gf180mcu_fd_sc_mcu7t5v0__fill_2
XFILLER_120_69 VDD VDD VSS VSS gf180mcu_fd_sc_mcu7t5v0__fillcap_8
XTAP_TAPCELL_ROW_81_1335 VDD VSS gf180mcu_fd_sc_mcu7t5v0__filltie
XFILLER_11_905 VDD VDD VSS VSS gf180mcu_fd_sc_mcu7t5v0__fillcap_4
XFILLER_22_242 VDD VDD VSS VSS gf180mcu_fd_sc_mcu7t5v0__fill_2
XFILLER_108_325 VDD VDD VSS VSS gf180mcu_fd_sc_mcu7t5v0__fillcap_4
XFILLER_124_807 VDD VDD VSS VSS gf180mcu_fd_sc_mcu7t5v0__fillcap_16
XFILLER_117_892 VDD VDD VSS VSS gf180mcu_fd_sc_mcu7t5v0__fill_2
XFILLER_104_520 VDD VDD VSS VSS gf180mcu_fd_sc_mcu7t5v0__fillcap_4
XFILLER_89_220 VDD VDD VSS VSS gf180mcu_fd_sc_mcu7t5v0__fill_2
XTAP_TAPCELL_ROW_92_1486 VDD VSS gf180mcu_fd_sc_mcu7t5v0__filltie
XFILLER_89_264 VDD VDD VSS VSS gf180mcu_fd_sc_mcu7t5v0__fillcap_16
XFILLER_104_597 VDD VDD VSS VSS gf180mcu_fd_sc_mcu7t5v0__fillcap_32
XFILLER_92_407 VDD VDD VSS VSS gf180mcu_fd_sc_mcu7t5v0__fill_1
XFILLER_92_429 VDD VDD VSS VSS gf180mcu_fd_sc_mcu7t5v0__fillcap_8
XFILLER_100_792 VDD VDD VSS VSS gf180mcu_fd_sc_mcu7t5v0__fillcap_8
XFILLER_73_632 VDD VDD VSS VSS gf180mcu_fd_sc_mcu7t5v0__fillcap_64
XFILLER_18_559 VDD VDD VSS VSS gf180mcu_fd_sc_mcu7t5v0__fillcap_4
XFILLER_45_323 VDD VDD VSS VSS gf180mcu_fd_sc_mcu7t5v0__fill_2
XFILLER_54_41 VDD VDD VSS VSS gf180mcu_fd_sc_mcu7t5v0__fillcap_4
XFILLER_13_242 VDD VDD VSS VSS gf180mcu_fd_sc_mcu7t5v0__fillcap_32
XFILLER_14_787 VDD VDD VSS VSS gf180mcu_fd_sc_mcu7t5v0__fill_1
XFILLER_41_562 VDD VDD VSS VSS gf180mcu_fd_sc_mcu7t5v0__fillcap_64
XTAP_TAPCELL_ROW_101_1593 VDD VSS gf180mcu_fd_sc_mcu7t5v0__filltie
XTAP_TAPCELL_ROW_11_432 VDD VSS gf180mcu_fd_sc_mcu7t5v0__filltie
XFILLER_9_246 VDD VDD VSS VSS gf180mcu_fd_sc_mcu7t5v0__fill_1
XFILLER_126_111 VDD VDD VSS VSS gf180mcu_fd_sc_mcu7t5v0__fill_2
XFILLER_9_279 VDD VDD VSS VSS gf180mcu_fd_sc_mcu7t5v0__fill_1
Xclkload16 _4156_/CLK clkload16/Z VDD VDD VSS VSS gf180mcu_fd_sc_mcu7t5v0__clkbuf_4
Xclkload27 _4147_/CLK clkload27/ZN VDD VDD VSS VSS gf180mcu_fd_sc_mcu7t5v0__inv_3
Xclkload49 _4094_/CLK clkload49/ZN VDD VDD VSS VSS gf180mcu_fd_sc_mcu7t5v0__clkinv_2
Xclkload38 _3755_/CLK clkload38/Z VDD VDD VSS VSS gf180mcu_fd_sc_mcu7t5v0__clkbuf_2
XFILLER_127_678 VDD VDD VSS VSS gf180mcu_fd_sc_mcu7t5v0__fillcap_16
XFILLER_126_177 VDD VDD VSS VSS gf180mcu_fd_sc_mcu7t5v0__fillcap_8
XFILLER_114_317 VDD VDD VSS VSS gf180mcu_fd_sc_mcu7t5v0__fillcap_8
XFILLER_95_212 VDD VDD VSS VSS gf180mcu_fd_sc_mcu7t5v0__fillcap_8
X_4070_ _4070_/D input92/Z _4166_/CLK _4070_/Q VDD VDD VSS VSS gf180mcu_fd_sc_mcu7t5v0__dffrnq_1
XFILLER_68_448 VDD VDD VSS VSS gf180mcu_fd_sc_mcu7t5v0__fillcap_4
X_3021_ _3954_/Q _4042_/Q _3041_/S _3954_/D VDD VDD VSS VSS gf180mcu_fd_sc_mcu7t5v0__mux2_2
XFILLER_83_418 VDD VDD VSS VSS gf180mcu_fd_sc_mcu7t5v0__fill_2
XTAP_TAPCELL_ROW_19_532 VDD VSS gf180mcu_fd_sc_mcu7t5v0__filltie
XFILLER_36_312 VDD VDD VSS VSS gf180mcu_fd_sc_mcu7t5v0__fill_2
XFILLER_37_857 VDD VDD VSS VSS gf180mcu_fd_sc_mcu7t5v0__fillcap_32
XFILLER_36_367 VDD VDD VSS VSS gf180mcu_fd_sc_mcu7t5v0__fillcap_16
XFILLER_63_142 VDD VDD VSS VSS gf180mcu_fd_sc_mcu7t5v0__fillcap_32
XFILLER_36_389 VDD VDD VSS VSS gf180mcu_fd_sc_mcu7t5v0__fill_1
XTAP_TAPCELL_ROW_47_896 VDD VSS gf180mcu_fd_sc_mcu7t5v0__filltie
X_3923_ _3923_/D _2279_/I _3978_/CLK _3923_/Q VDD VDD VSS VSS gf180mcu_fd_sc_mcu7t5v0__dffrnq_1
X_3854_ _3854_/D clkload7/I _3854_/Q VDD VDD VSS VSS gf180mcu_fd_sc_mcu7t5v0__dffq_1
XTAP_TAPCELL_ROW_119_1832 VDD VSS gf180mcu_fd_sc_mcu7t5v0__filltie
XFILLER_118_601 VDD VDD VSS VSS gf180mcu_fd_sc_mcu7t5v0__fill_2
X_3785_ _3785_/D _3864_/CLK _3785_/Q VDD VDD VSS VSS gf180mcu_fd_sc_mcu7t5v0__dffq_1
XFILLER_106_807 VDD VDD VSS VSS gf180mcu_fd_sc_mcu7t5v0__fillcap_32
X_2736_ _3823_/Q place88/Z _2746_/S _3823_/D VDD VDD VSS VSS gf180mcu_fd_sc_mcu7t5v0__mux2_2
XFILLER_99_562 VDD VDD VSS VSS gf180mcu_fd_sc_mcu7t5v0__fillcap_32
XFILLER_87_702 VDD VDD VSS VSS gf180mcu_fd_sc_mcu7t5v0__fillcap_64
X_2598_ _3764_/Q place83/Z _2598_/S _3764_/D VDD VDD VSS VSS gf180mcu_fd_sc_mcu7t5v0__mux2_2
XFILLER_115_69 VDD VDD VSS VSS gf180mcu_fd_sc_mcu7t5v0__fill_1
X_3219_ _4048_/Q _4016_/Q _4129_/D _4048_/D VDD VDD VSS VSS gf180mcu_fd_sc_mcu7t5v0__mux2_2
XFILLER_28_802 VDD VDD VSS VSS gf180mcu_fd_sc_mcu7t5v0__fill_2
XFILLER_28_868 VDD VDD VSS VSS gf180mcu_fd_sc_mcu7t5v0__fillcap_4
XFILLER_55_632 VDD VDD VSS VSS gf180mcu_fd_sc_mcu7t5v0__fillcap_16
XFILLER_67_492 VDD VDD VSS VSS gf180mcu_fd_sc_mcu7t5v0__fillcap_64
XFILLER_131_46 VDD VDD VSS VSS gf180mcu_fd_sc_mcu7t5v0__fill_1
XFILLER_15_507 VDD VDD VSS VSS gf180mcu_fd_sc_mcu7t5v0__fillcap_8
XFILLER_11_702 VDD VDD VSS VSS gf180mcu_fd_sc_mcu7t5v0__fillcap_16
XFILLER_10_223 VDD VDD VSS VSS gf180mcu_fd_sc_mcu7t5v0__fill_2
XFILLER_108_100 VDD VDD VSS VSS gf180mcu_fd_sc_mcu7t5v0__fillcap_4
XFILLER_11_768 VDD VDD VSS VSS gf180mcu_fd_sc_mcu7t5v0__fill_2
XFILLER_108_122 VDD VDD VSS VSS gf180mcu_fd_sc_mcu7t5v0__fillcap_16
XTAP_TAPCELL_ROW_94_1504 VDD VSS gf180mcu_fd_sc_mcu7t5v0__filltie
XFILLER_6_238 VDD VDD VSS VSS gf180mcu_fd_sc_mcu7t5v0__fillcap_4
XFILLER_108_177 VDD VDD VSS VSS gf180mcu_fd_sc_mcu7t5v0__fillcap_16
XFILLER_3_912 VDD VDD VSS VSS gf180mcu_fd_sc_mcu7t5v0__fillcap_16
XFILLER_123_136 VDD VDD VSS VSS gf180mcu_fd_sc_mcu7t5v0__fillcap_4
XFILLER_2_422 VDD VDD VSS VSS gf180mcu_fd_sc_mcu7t5v0__fillcap_32
XFILLER_77_212 VDD VDD VSS VSS gf180mcu_fd_sc_mcu7t5v0__fillcap_32
XFILLER_45_142 VDD VDD VSS VSS gf180mcu_fd_sc_mcu7t5v0__fillcap_8
XFILLER_61_602 VDD VDD VSS VSS gf180mcu_fd_sc_mcu7t5v0__fill_2
XFILLER_18_378 VDD VDD VSS VSS gf180mcu_fd_sc_mcu7t5v0__fillcap_4
XFILLER_45_186 VDD VDD VSS VSS gf180mcu_fd_sc_mcu7t5v0__fillcap_16
XTAP_TAPCELL_ROW_103_1622 VDD VSS gf180mcu_fd_sc_mcu7t5v0__filltie
XTAP_TAPCELL_ROW_44_855 VDD VSS gf180mcu_fd_sc_mcu7t5v0__filltie
XFILLER_61_657 VDD VDD VSS VSS gf180mcu_fd_sc_mcu7t5v0__fill_2
XFILLER_81_72 VDD VDD VSS VSS gf180mcu_fd_sc_mcu7t5v0__fillcap_32
XTAP_TAPCELL_ROW_132_2018 VDD VSS gf180mcu_fd_sc_mcu7t5v0__filltie
XTAP_TAPCELL_ROW_132_2007 VDD VSS gf180mcu_fd_sc_mcu7t5v0__filltie
X_3570_ _3784_/Q _3792_/Q _3800_/Q _3808_/Q place76/Z place75/Z _3570_/Z VDD VDD VSS
+ VSS gf180mcu_fd_sc_mcu7t5v0__mux4_1
X_2521_ _3732_/Q _4074_/Q _2521_/S _3732_/D VDD VDD VSS VSS gf180mcu_fd_sc_mcu7t5v0__mux2_2
XFILLER_127_486 VDD VDD VSS VSS gf180mcu_fd_sc_mcu7t5v0__fillcap_4
XFILLER_5_282 VDD VDD VSS VSS gf180mcu_fd_sc_mcu7t5v0__fillcap_32
XTAP_TAPCELL_ROW_114_1773 VDD VSS gf180mcu_fd_sc_mcu7t5v0__filltie
XFILLER_114_147 VDD VDD VSS VSS gf180mcu_fd_sc_mcu7t5v0__fillcap_16
XTAP_TAPCELL_ROW_114_1762 VDD VSS gf180mcu_fd_sc_mcu7t5v0__filltie
X_2452_ place82/Z _3701_/Q _2466_/S _3701_/D VDD VDD VSS VSS gf180mcu_fd_sc_mcu7t5v0__mux2_2
XFILLER_69_702 VDD VDD VSS VSS gf180mcu_fd_sc_mcu7t5v0__fillcap_8
XPHY_EDGE_ROW_18_Right_18 VDD VSS gf180mcu_fd_sc_mcu7t5v0__endcap
X_2383_ _3670_/Q _4068_/Q _2395_/S _3670_/D VDD VDD VSS VSS gf180mcu_fd_sc_mcu7t5v0__mux2_2
XFILLER_39_2 VDD VDD VSS VSS gf180mcu_fd_sc_mcu7t5v0__fillcap_16
X_4122_ _4122_/D _4157_/RN _4123_/CLK _4122_/Q VDD VDD VSS VSS gf180mcu_fd_sc_mcu7t5v0__dffrnq_1
X_4053_ _4053_/D input92/Z _4129_/CLK _4053_/Q VDD VDD VSS VSS gf180mcu_fd_sc_mcu7t5v0__dffrnq_1
X_3004_ _3946_/Q _4034_/Q _3041_/S _3946_/D VDD VDD VSS VSS gf180mcu_fd_sc_mcu7t5v0__mux2_2
XFILLER_37_632 VDD VDD VSS VSS gf180mcu_fd_sc_mcu7t5v0__fillcap_4
XFILLER_49_492 VDD VDD VSS VSS gf180mcu_fd_sc_mcu7t5v0__fillcap_4
XFILLER_64_451 VDD VDD VSS VSS gf180mcu_fd_sc_mcu7t5v0__fillcap_4
XFILLER_91_270 VDD VDD VSS VSS gf180mcu_fd_sc_mcu7t5v0__fill_2
XFILLER_25_838 VDD VDD VSS VSS gf180mcu_fd_sc_mcu7t5v0__fill_2
XTAP_TAPCELL_ROW_65_1127 VDD VSS gf180mcu_fd_sc_mcu7t5v0__filltie
XPHY_EDGE_ROW_27_Right_27 VDD VSS gf180mcu_fd_sc_mcu7t5v0__endcap
XFILLER_36_197 VDD VDD VSS VSS gf180mcu_fd_sc_mcu7t5v0__fill_1
X_3906_ _3906_/D _2279_/I _4114_/CLK _3906_/Q VDD VDD VSS VSS gf180mcu_fd_sc_mcu7t5v0__dffrnq_1
XFILLER_51_156 VDD VDD VSS VSS gf180mcu_fd_sc_mcu7t5v0__fill_1
XFILLER_119_932 VDD VDD VSS VSS gf180mcu_fd_sc_mcu7t5v0__fill_2
X_3837_ _3837_/D _4156_/CLK _3837_/Q VDD VDD VSS VSS gf180mcu_fd_sc_mcu7t5v0__dffq_1
X_3768_ _3768_/D clkload9/I _3768_/Q VDD VDD VSS VSS gf180mcu_fd_sc_mcu7t5v0__dffq_1
XFILLER_106_637 VDD VDD VSS VSS gf180mcu_fd_sc_mcu7t5v0__fillcap_4
X_3699_ _3699_/D _4072_/CLK _3699_/Q VDD VDD VSS VSS gf180mcu_fd_sc_mcu7t5v0__dffq_1
XFILLER_105_158 VDD VDD VSS VSS gf180mcu_fd_sc_mcu7t5v0__fillcap_4
XTAP_TAPCELL_ROW_76_1278 VDD VSS gf180mcu_fd_sc_mcu7t5v0__filltie
XPHY_EDGE_ROW_36_Right_36 VDD VSS gf180mcu_fd_sc_mcu7t5v0__endcap
XFILLER_120_117 VDD VDD VSS VSS gf180mcu_fd_sc_mcu7t5v0__fill_1
XFILLER_87_510 VDD VDD VSS VSS gf180mcu_fd_sc_mcu7t5v0__fillcap_32
XFILLER_59_212 VDD VDD VSS VSS gf180mcu_fd_sc_mcu7t5v0__fillcap_16
XFILLER_59_201 VDD VDD VSS VSS gf180mcu_fd_sc_mcu7t5v0__fill_2
XFILLER_102_865 VDD VDD VSS VSS gf180mcu_fd_sc_mcu7t5v0__fillcap_8
XFILLER_99_392 VDD VDD VSS VSS gf180mcu_fd_sc_mcu7t5v0__fillcap_4
XFILLER_27_142 VDD VDD VSS VSS gf180mcu_fd_sc_mcu7t5v0__fillcap_16
XFILLER_55_462 VDD VDD VSS VSS gf180mcu_fd_sc_mcu7t5v0__fillcap_4
XFILLER_15_326 VDD VDD VSS VSS gf180mcu_fd_sc_mcu7t5v0__fillcap_16
XPHY_EDGE_ROW_45_Right_45 VDD VSS gf180mcu_fd_sc_mcu7t5v0__endcap
XPHY_EDGE_ROW_106_Left_239 VDD VSS gf180mcu_fd_sc_mcu7t5v0__endcap
XTAP_TAPCELL_ROW_41_814 VDD VSS gf180mcu_fd_sc_mcu7t5v0__filltie
XTAP_TAPCELL_ROW_41_825 VDD VSS gf180mcu_fd_sc_mcu7t5v0__filltie
XFILLER_70_476 VDD VDD VSS VSS gf180mcu_fd_sc_mcu7t5v0__fill_2
XFILLER_70_465 VDD VDD VSS VSS gf180mcu_fd_sc_mcu7t5v0__fillcap_4
XFILLER_129_729 VDD VDD VSS VSS gf180mcu_fd_sc_mcu7t5v0__fill_1
XFILLER_51_42 VDD VDD VSS VSS gf180mcu_fd_sc_mcu7t5v0__fillcap_16
XFILLER_128_239 VDD VDD VSS VSS gf180mcu_fd_sc_mcu7t5v0__fillcap_4
XTAP_TAPCELL_ROW_21_560 VDD VSS gf180mcu_fd_sc_mcu7t5v0__filltie
XPHY_EDGE_ROW_54_Right_54 VDD VSS gf180mcu_fd_sc_mcu7t5v0__endcap
XPHY_EDGE_ROW_115_Left_248 VDD VSS gf180mcu_fd_sc_mcu7t5v0__endcap
XFILLER_78_521 VDD VDD VSS VSS gf180mcu_fd_sc_mcu7t5v0__fillcap_4
XTAP_TAPCELL_ROW_49_925 VDD VSS gf180mcu_fd_sc_mcu7t5v0__filltie
XFILLER_19_632 VDD VDD VSS VSS gf180mcu_fd_sc_mcu7t5v0__fill_2
XFILLER_19_665 VDD VDD VSS VSS gf180mcu_fd_sc_mcu7t5v0__fillcap_4
XPHY_EDGE_ROW_63_Right_63 VDD VSS gf180mcu_fd_sc_mcu7t5v0__endcap
XPHY_EDGE_ROW_124_Left_257 VDD VSS gf180mcu_fd_sc_mcu7t5v0__endcap
Xplace71 place71/I place71/Z VDD VDD VSS VSS gf180mcu_fd_sc_mcu7t5v0__buf_8
Xplace60 place60/I _2357_/S VDD VDD VSS VSS gf180mcu_fd_sc_mcu7t5v0__buf_8
Xplace82 _4067_/Q place82/Z VDD VDD VSS VSS gf180mcu_fd_sc_mcu7t5v0__buf_8
XTAP_TAPCELL_ROW_29_660 VDD VSS gf180mcu_fd_sc_mcu7t5v0__filltie
XFILLER_46_473 VDD VDD VSS VSS gf180mcu_fd_sc_mcu7t5v0__fillcap_8
XFILLER_62_933 VDD VDD VSS VSS gf180mcu_fd_sc_mcu7t5v0__fill_1
XFILLER_22_819 VDD VDD VSS VSS gf180mcu_fd_sc_mcu7t5v0__fill_1
X_1952_ _4082_/Q _4081_/Q _4083_/Q _1952_/Z VDD VDD VSS VSS gf180mcu_fd_sc_mcu7t5v0__and3_1
XFILLER_14_381 VDD VDD VSS VSS gf180mcu_fd_sc_mcu7t5v0__fillcap_4
XFILLER_119_228 VDD VDD VSS VSS gf180mcu_fd_sc_mcu7t5v0__fill_2
X_1883_ _1935_/A4 _1883_/A2 _1883_/B1 _1883_/B2 _1884_/C VDD VDD VSS VSS gf180mcu_fd_sc_mcu7t5v0__aoi22_1
XTAP_TAPCELL_ROW_60_1068 VDD VSS gf180mcu_fd_sc_mcu7t5v0__filltie
XPHY_EDGE_ROW_72_Right_72 VDD VSS gf180mcu_fd_sc_mcu7t5v0__endcap
XFILLER_115_434 VDD VDD VSS VSS gf180mcu_fd_sc_mcu7t5v0__fill_2
X_3553_ _3758_/Q _3814_/Q _3822_/Q _3830_/Q _4116_/Q place75/Z _3553_/Z VDD VDD VSS
+ VSS gf180mcu_fd_sc_mcu7t5v0__mux4_1
XFILLER_131_916 VDD VDD VSS VSS gf180mcu_fd_sc_mcu7t5v0__fillcap_16
X_3484_ _3482_/Z _3483_/Z _4101_/Q _3484_/Z VDD VDD VSS VSS gf180mcu_fd_sc_mcu7t5v0__mux2_2
XFILLER_103_629 VDD VDD VSS VSS gf180mcu_fd_sc_mcu7t5v0__fill_1
XFILLER_96_362 VDD VDD VSS VSS gf180mcu_fd_sc_mcu7t5v0__fillcap_16
X_4105_ _4105_/D _4157_/RN _4109_/CLK _4105_/Q VDD VDD VSS VSS gf180mcu_fd_sc_mcu7t5v0__dffrnq_1
XFILLER_96_395 VDD VDD VSS VSS gf180mcu_fd_sc_mcu7t5v0__fillcap_4
XFILLER_96_384 VDD VDD VSS VSS gf180mcu_fd_sc_mcu7t5v0__fill_1
XFILLER_84_546 VDD VDD VSS VSS gf180mcu_fd_sc_mcu7t5v0__fillcap_4
XPHY_EDGE_ROW_81_Right_81 VDD VSS gf180mcu_fd_sc_mcu7t5v0__endcap
XTAP_TAPCELL_ROW_127_1942 VDD VSS gf180mcu_fd_sc_mcu7t5v0__filltie
XTAP_TAPCELL_ROW_127_1931 VDD VSS gf180mcu_fd_sc_mcu7t5v0__filltie
X_4036_ _4036_/D _4148_/RN _4036_/CLK _4036_/Q VDD VDD VSS VSS gf180mcu_fd_sc_mcu7t5v0__dffrnq_1
XFILLER_53_933 VDD VDD VSS VSS gf180mcu_fd_sc_mcu7t5v0__fill_1
XFILLER_24_123 VDD VDD VSS VSS gf180mcu_fd_sc_mcu7t5v0__fillcap_32
XFILLER_52_421 VDD VDD VSS VSS gf180mcu_fd_sc_mcu7t5v0__fill_1
XFILLER_21_830 VDD VDD VSS VSS gf180mcu_fd_sc_mcu7t5v0__fillcap_8
XPHY_EDGE_ROW_90_Right_90 VDD VSS gf180mcu_fd_sc_mcu7t5v0__endcap
XFILLER_20_384 VDD VDD VSS VSS gf180mcu_fd_sc_mcu7t5v0__fill_1
XFILLER_125_209 VDD VDD VSS VSS gf180mcu_fd_sc_mcu7t5v0__fill_1
XFILLER_119_762 VDD VDD VSS VSS gf180mcu_fd_sc_mcu7t5v0__fillcap_8
XFILLER_119_784 VDD VDD VSS VSS gf180mcu_fd_sc_mcu7t5v0__fill_2
XFILLER_118_272 VDD VDD VSS VSS gf180mcu_fd_sc_mcu7t5v0__fill_1
XFILLER_21_67 VDD VDD VSS VSS gf180mcu_fd_sc_mcu7t5v0__fill_2
Xoutput170 _2273_/ZN s_axi_rdata[30] VDD VDD VSS VSS gf180mcu_fd_sc_mcu7t5v0__dlyb_1
XFILLER_97_49 VDD VDD VSS VSS gf180mcu_fd_sc_mcu7t5v0__fillcap_16
Xoutput181 _4109_/Q uart_tx_pin VDD VDD VSS VSS gf180mcu_fd_sc_mcu7t5v0__dlyb_1
XTAP_TAPCELL_ROW_7_377 VDD VSS gf180mcu_fd_sc_mcu7t5v0__filltie
XTAP_TAPCELL_ROW_89_1447 VDD VSS gf180mcu_fd_sc_mcu7t5v0__filltie
XFILLER_87_384 VDD VDD VSS VSS gf180mcu_fd_sc_mcu7t5v0__fillcap_8
XFILLER_90_527 VDD VDD VSS VSS gf180mcu_fd_sc_mcu7t5v0__fillcap_32
XFILLER_16_613 VDD VDD VSS VSS gf180mcu_fd_sc_mcu7t5v0__fillcap_8
XFILLER_28_473 VDD VDD VSS VSS gf180mcu_fd_sc_mcu7t5v0__fillcap_8
XFILLER_44_933 VDD VDD VSS VSS gf180mcu_fd_sc_mcu7t5v0__fill_1
XTAP_TAPCELL_ROW_26_630 VDD VSS gf180mcu_fd_sc_mcu7t5v0__filltie
XTAP_TAPCELL_ROW_54_983 VDD VSS gf180mcu_fd_sc_mcu7t5v0__filltie
XTAP_TAPCELL_ROW_54_994 VDD VSS gf180mcu_fd_sc_mcu7t5v0__filltie
XFILLER_8_801 VDD VDD VSS VSS gf180mcu_fd_sc_mcu7t5v0__fillcap_4
XFILLER_7_69 VDD VDD VSS VSS gf180mcu_fd_sc_mcu7t5v0__fill_1
XFILLER_112_437 VDD VDD VSS VSS gf180mcu_fd_sc_mcu7t5v0__fillcap_4
XTAP_TAPCELL_ROW_111_1732 VDD VSS gf180mcu_fd_sc_mcu7t5v0__filltie
X_2220_ _3941_/Q place63/Z _2220_/B _2223_/A1 VDD VDD VSS VSS gf180mcu_fd_sc_mcu7t5v0__aoi21_1
XFILLER_87_60 VDD VDD VSS VSS gf180mcu_fd_sc_mcu7t5v0__fillcap_8
XFILLER_3_594 VDD VDD VSS VSS gf180mcu_fd_sc_mcu7t5v0__fillcap_16
X_2151_ _2216_/B1 _3375_/A3 _2156_/A2 VDD VDD VSS VSS gf180mcu_fd_sc_mcu7t5v0__nand2_1
XFILLER_39_749 VDD VDD VSS VSS gf180mcu_fd_sc_mcu7t5v0__fillcap_16
XFILLER_66_524 VDD VDD VSS VSS gf180mcu_fd_sc_mcu7t5v0__fill_1
X_2082_ place71/Z place52/Z _2080_/Z _2083_/B VDD VDD VSS VSS gf180mcu_fd_sc_mcu7t5v0__nand3_1
XFILLER_94_877 VDD VDD VSS VSS gf180mcu_fd_sc_mcu7t5v0__fillcap_16
XFILLER_47_760 VDD VDD VSS VSS gf180mcu_fd_sc_mcu7t5v0__fillcap_8
XFILLER_35_933 VDD VDD VSS VSS gf180mcu_fd_sc_mcu7t5v0__fill_1
XFILLER_46_270 VDD VDD VSS VSS gf180mcu_fd_sc_mcu7t5v0__fill_1
XFILLER_22_605 VDD VDD VSS VSS gf180mcu_fd_sc_mcu7t5v0__fillcap_32
XFILLER_34_454 VDD VDD VSS VSS gf180mcu_fd_sc_mcu7t5v0__fill_1
XFILLER_50_925 VDD VDD VSS VSS gf180mcu_fd_sc_mcu7t5v0__fillcap_8
XTAP_TAPCELL_ROW_122_1872 VDD VSS gf180mcu_fd_sc_mcu7t5v0__filltie
X_1935_ _1935_/A1 _1935_/A2 _2013_/A4 _1935_/A4 _1935_/Z VDD VDD VSS VSS gf180mcu_fd_sc_mcu7t5v0__and4_1
XTAP_TAPCELL_ROW_32_699 VDD VSS gf180mcu_fd_sc_mcu7t5v0__filltie
X_1866_ _1866_/A1 _1866_/A2 _1866_/B _1884_/A1 VDD VDD VSS VSS gf180mcu_fd_sc_mcu7t5v0__oai21_1
X_3605_ _3627_/I1 _4160_/Q _3605_/S _4160_/D VDD VDD VSS VSS gf180mcu_fd_sc_mcu7t5v0__mux2_2
X_1797_ _4110_/Q _4111_/Q _4113_/Q _4112_/Q _1797_/Z VDD VDD VSS VSS gf180mcu_fd_sc_mcu7t5v0__or4_2
Xinput94 s_axi_araddr[1] input94/Z VDD VDD VSS VSS gf180mcu_fd_sc_mcu7t5v0__dlyb_1
X_3536_ _4120_/Q _2578_/Z _3537_/A2 VDD VDD VSS VSS gf180mcu_fd_sc_mcu7t5v0__nand2_1
XFILLER_131_702 VDD VDD VSS VSS gf180mcu_fd_sc_mcu7t5v0__fillcap_4
XTAP_TAPCELL_ROW_73_1237 VDD VSS gf180mcu_fd_sc_mcu7t5v0__filltie
X_3467_ _3471_/A1 _3463_/Z _3467_/B _4105_/D VDD VDD VSS VSS gf180mcu_fd_sc_mcu7t5v0__oai21_1
XFILLER_97_671 VDD VDD VSS VSS gf180mcu_fd_sc_mcu7t5v0__fillcap_4
X_3398_ place79/Z _3372_/Z _3399_/A2 VDD VDD VSS VSS gf180mcu_fd_sc_mcu7t5v0__nand2_1
X_2418_ _3686_/Q _4068_/Q _2430_/S _3686_/D VDD VDD VSS VSS gf180mcu_fd_sc_mcu7t5v0__mux2_2
XFILLER_84_321 VDD VDD VSS VSS gf180mcu_fd_sc_mcu7t5v0__fill_2
XTAP_TAPCELL_ROW_4_336 VDD VSS gf180mcu_fd_sc_mcu7t5v0__filltie
XFILLER_57_524 VDD VDD VSS VSS gf180mcu_fd_sc_mcu7t5v0__fillcap_8
X_2349_ _3656_/Q place81/Z _2357_/S _3656_/D VDD VDD VSS VSS gf180mcu_fd_sc_mcu7t5v0__mux2_2
XFILLER_123_58 VDD VDD VSS VSS gf180mcu_fd_sc_mcu7t5v0__fillcap_8
XFILLER_85_877 VDD VDD VSS VSS gf180mcu_fd_sc_mcu7t5v0__fillcap_4
X_4019_ _4019_/D _4148_/RN _4146_/CLK _4019_/Q VDD VDD VSS VSS gf180mcu_fd_sc_mcu7t5v0__dffrnq_1
XFILLER_84_387 VDD VDD VSS VSS gf180mcu_fd_sc_mcu7t5v0__fillcap_64
XFILLER_84_376 VDD VDD VSS VSS gf180mcu_fd_sc_mcu7t5v0__fillcap_8
XFILLER_16_34 VDD VDD VSS VSS gf180mcu_fd_sc_mcu7t5v0__fill_1
XTAP_TAPCELL_ROW_84_1377 VDD VSS gf180mcu_fd_sc_mcu7t5v0__filltie
XFILLER_16_45 VDD VDD VSS VSS gf180mcu_fd_sc_mcu7t5v0__fillcap_4
XFILLER_13_605 VDD VDD VSS VSS gf180mcu_fd_sc_mcu7t5v0__fillcap_8
XPHY_EDGE_ROW_0_Right_0 VDD VSS gf180mcu_fd_sc_mcu7t5v0__endcap
XFILLER_80_593 VDD VDD VSS VSS gf180mcu_fd_sc_mcu7t5v0__fill_2
XFILLER_12_104 VDD VDD VSS VSS gf180mcu_fd_sc_mcu7t5v0__fill_1
XFILLER_52_295 VDD VDD VSS VSS gf180mcu_fd_sc_mcu7t5v0__fillcap_4
XFILLER_40_457 VDD VDD VSS VSS gf180mcu_fd_sc_mcu7t5v0__fillcap_64
XTAP_TAPCELL_ROW_51_953 VDD VSS gf180mcu_fd_sc_mcu7t5v0__filltie
XFILLER_107_754 VDD VDD VSS VSS gf180mcu_fd_sc_mcu7t5v0__fill_1
XFILLER_106_242 VDD VDD VSS VSS gf180mcu_fd_sc_mcu7t5v0__fill_2
XFILLER_121_212 VDD VDD VSS VSS gf180mcu_fd_sc_mcu7t5v0__fillcap_64
XFILLER_79_137 VDD VDD VSS VSS gf180mcu_fd_sc_mcu7t5v0__fill_2
XFILLER_94_107 VDD VDD VSS VSS gf180mcu_fd_sc_mcu7t5v0__fillcap_32
XFILLER_130_790 VDD VDD VSS VSS gf180mcu_fd_sc_mcu7t5v0__fillcap_8
XFILLER_48_524 VDD VDD VSS VSS gf180mcu_fd_sc_mcu7t5v0__fill_1
XFILLER_76_877 VDD VDD VSS VSS gf180mcu_fd_sc_mcu7t5v0__fillcap_16
XFILLER_36_719 VDD VDD VSS VSS gf180mcu_fd_sc_mcu7t5v0__fill_1
XFILLER_63_538 VDD VDD VSS VSS gf180mcu_fd_sc_mcu7t5v0__fillcap_16
XPHY_EDGE_ROW_121_Right_121 VDD VSS gf180mcu_fd_sc_mcu7t5v0__endcap
XFILLER_17_933 VDD VDD VSS VSS gf180mcu_fd_sc_mcu7t5v0__fill_1
XFILLER_28_292 VDD VDD VSS VSS gf180mcu_fd_sc_mcu7t5v0__fillcap_16
XFILLER_32_903 VDD VDD VSS VSS gf180mcu_fd_sc_mcu7t5v0__fill_1
XFILLER_44_752 VDD VDD VSS VSS gf180mcu_fd_sc_mcu7t5v0__fill_2
XFILLER_129_334 VDD VDD VSS VSS gf180mcu_fd_sc_mcu7t5v0__fillcap_4
XFILLER_125_540 VDD VDD VSS VSS gf180mcu_fd_sc_mcu7t5v0__fillcap_4
XFILLER_125_562 VDD VDD VSS VSS gf180mcu_fd_sc_mcu7t5v0__fillcap_64
XFILLER_113_702 VDD VDD VSS VSS gf180mcu_fd_sc_mcu7t5v0__fillcap_16
X_3321_ _3902_/Q _3323_/A2 _3335_/B VDD VDD VSS VSS gf180mcu_fd_sc_mcu7t5v0__and2_1
XFILLER_112_267 VDD VDD VSS VSS gf180mcu_fd_sc_mcu7t5v0__fillcap_32
X_3252_ _4075_/Q _4077_/Q _4076_/Q _3278_/A2 VDD VDD VSS VSS gf180mcu_fd_sc_mcu7t5v0__oai21_1
X_3183_ _4031_/Q _3999_/Q _4129_/D _4031_/D VDD VDD VSS VSS gf180mcu_fd_sc_mcu7t5v0__mux2_2
XFILLER_21_2 VDD VDD VSS VSS gf180mcu_fd_sc_mcu7t5v0__fillcap_16
XFILLER_39_524 VDD VDD VSS VSS gf180mcu_fd_sc_mcu7t5v0__fillcap_16
X_2203_ _2199_/Z _2200_/Z _2201_/Z _2202_/Z place77/Z _4094_/Q _2203_/Z VDD VDD VSS
+ VSS gf180mcu_fd_sc_mcu7t5v0__mux4_1
X_2134_ _2134_/A1 _2167_/A2 _2134_/Z VDD VDD VSS VSS gf180mcu_fd_sc_mcu7t5v0__and2_1
XTAP_TAPCELL_ROW_124_1901 VDD VSS gf180mcu_fd_sc_mcu7t5v0__filltie
XFILLER_54_527 VDD VDD VSS VSS gf180mcu_fd_sc_mcu7t5v0__fillcap_32
XFILLER_66_387 VDD VDD VSS VSS gf180mcu_fd_sc_mcu7t5v0__fillcap_16
X_2065_ place71/Z _2097_/A2 _2097_/A3 _2064_/Z _2067_/A2 VDD VDD VSS VSS gf180mcu_fd_sc_mcu7t5v0__nand4_1
XFILLER_82_869 VDD VDD VSS VSS gf180mcu_fd_sc_mcu7t5v0__fillcap_4
XFILLER_35_763 VDD VDD VSS VSS gf180mcu_fd_sc_mcu7t5v0__fill_2
XTAP_TAPCELL_ROW_37_769 VDD VSS gf180mcu_fd_sc_mcu7t5v0__filltie
XFILLER_34_262 VDD VDD VSS VSS gf180mcu_fd_sc_mcu7t5v0__fillcap_16
XFILLER_22_457 VDD VDD VSS VSS gf180mcu_fd_sc_mcu7t5v0__fill_1
X_2898_ _4033_/Q _2900_/S _2899_/B VDD VDD VSS VSS gf180mcu_fd_sc_mcu7t5v0__nand2_1
X_1918_ _3893_/Q _3894_/Q _1919_/C VDD VDD VSS VSS gf180mcu_fd_sc_mcu7t5v0__nor2_1
X_1849_ _1820_/Z _1822_/Z _1919_/B VDD VDD VSS VSS gf180mcu_fd_sc_mcu7t5v0__nor2_1
XTAP_TAPCELL_ROW_9_406 VDD VSS gf180mcu_fd_sc_mcu7t5v0__filltie
XFILLER_2_807 VDD VDD VSS VSS gf180mcu_fd_sc_mcu7t5v0__fillcap_64
XFILLER_103_201 VDD VDD VSS VSS gf180mcu_fd_sc_mcu7t5v0__fillcap_8
X_3519_ _3519_/A1 _3519_/A2 _3519_/A3 _3522_/A2 VDD VDD VSS VSS gf180mcu_fd_sc_mcu7t5v0__nand3_1
XFILLER_103_256 VDD VDD VSS VSS gf180mcu_fd_sc_mcu7t5v0__fillcap_16
XFILLER_76_107 VDD VDD VSS VSS gf180mcu_fd_sc_mcu7t5v0__fillcap_64
XFILLER_85_652 VDD VDD VSS VSS gf180mcu_fd_sc_mcu7t5v0__fill_1
XFILLER_58_877 VDD VDD VSS VSS gf180mcu_fd_sc_mcu7t5v0__fillcap_32
XTAP_TAPCELL_ROW_86_1406 VDD VSS gf180mcu_fd_sc_mcu7t5v0__filltie
XFILLER_73_836 VDD VDD VSS VSS gf180mcu_fd_sc_mcu7t5v0__fillcap_4
XFILLER_72_313 VDD VDD VSS VSS gf180mcu_fd_sc_mcu7t5v0__fill_2
XFILLER_26_730 VDD VDD VSS VSS gf180mcu_fd_sc_mcu7t5v0__fillcap_4
XFILLER_53_582 VDD VDD VSS VSS gf180mcu_fd_sc_mcu7t5v0__fill_2
XFILLER_40_243 VDD VDD VSS VSS gf180mcu_fd_sc_mcu7t5v0__fill_2
XFILLER_41_766 VDD VDD VSS VSS gf180mcu_fd_sc_mcu7t5v0__fillcap_4
Xclkbuf_leaf_20_clk clkload5/I _4126_/CLK VDD VDD VSS VSS gf180mcu_fd_sc_mcu7t5v0__clkbuf_8
XFILLER_127_838 VDD VDD VSS VSS gf180mcu_fd_sc_mcu7t5v0__fill_2
XTAP_TAPCELL_ROW_97_1546 VDD VSS gf180mcu_fd_sc_mcu7t5v0__filltie
XFILLER_107_540 VDD VDD VSS VSS gf180mcu_fd_sc_mcu7t5v0__fillcap_4
XFILLER_107_562 VDD VDD VSS VSS gf180mcu_fd_sc_mcu7t5v0__fillcap_16
XFILLER_107_551 VDD VDD VSS VSS gf180mcu_fd_sc_mcu7t5v0__fillcap_4
XFILLER_4_155 VDD VDD VSS VSS gf180mcu_fd_sc_mcu7t5v0__fillcap_4
XFILLER_122_521 VDD VDD VSS VSS gf180mcu_fd_sc_mcu7t5v0__fillcap_4
XFILLER_4_37 VDD VDD VSS VSS gf180mcu_fd_sc_mcu7t5v0__fillcap_4
XFILLER_4_177 VDD VDD VSS VSS gf180mcu_fd_sc_mcu7t5v0__fillcap_8
XFILLER_95_438 VDD VDD VSS VSS gf180mcu_fd_sc_mcu7t5v0__fillcap_8
XFILLER_95_416 VDD VDD VSS VSS gf180mcu_fd_sc_mcu7t5v0__fillcap_4
XFILLER_76_652 VDD VDD VSS VSS gf180mcu_fd_sc_mcu7t5v0__fillcap_8
XFILLER_36_505 VDD VDD VSS VSS gf180mcu_fd_sc_mcu7t5v0__fillcap_16
XFILLER_36_527 VDD VDD VSS VSS gf180mcu_fd_sc_mcu7t5v0__fillcap_8
XFILLER_48_387 VDD VDD VSS VSS gf180mcu_fd_sc_mcu7t5v0__fillcap_16
XFILLER_91_644 VDD VDD VSS VSS gf180mcu_fd_sc_mcu7t5v0__fill_1
XTAP_TAPCELL_ROW_106_1664 VDD VSS gf180mcu_fd_sc_mcu7t5v0__filltie
XFILLER_90_154 VDD VDD VSS VSS gf180mcu_fd_sc_mcu7t5v0__fillcap_16
XTAP_TAPCELL_ROW_34_728 VDD VSS gf180mcu_fd_sc_mcu7t5v0__filltie
X_3870_ _3870_/D _4057_/CLK _3870_/Q VDD VDD VSS VSS gf180mcu_fd_sc_mcu7t5v0__dffq_1
XTAP_TAPCELL_ROW_14_474 VDD VSS gf180mcu_fd_sc_mcu7t5v0__filltie
XTAP_TAPCELL_ROW_14_463 VDD VSS gf180mcu_fd_sc_mcu7t5v0__filltie
X_2821_ place89/Z _3862_/Q _2833_/S _3862_/D VDD VDD VSS VSS gf180mcu_fd_sc_mcu7t5v0__mux2_2
XFILLER_31_276 VDD VDD VSS VSS gf180mcu_fd_sc_mcu7t5v0__fillcap_4
XFILLER_129_142 VDD VDD VSS VSS gf180mcu_fd_sc_mcu7t5v0__fillcap_4
Xclkbuf_leaf_11_clk clkload1/I _4036_/CLK VDD VDD VSS VSS gf180mcu_fd_sc_mcu7t5v0__clkbuf_8
X_2752_ _3830_/Q place89/Z _2764_/S _3830_/D VDD VDD VSS VSS gf180mcu_fd_sc_mcu7t5v0__mux2_2
XFILLER_31_298 VDD VDD VSS VSS gf180mcu_fd_sc_mcu7t5v0__fillcap_8
XFILLER_117_337 VDD VDD VSS VSS gf180mcu_fd_sc_mcu7t5v0__fillcap_8
X_2683_ place88/Z _3799_/Q _2693_/S _3799_/D VDD VDD VSS VSS gf180mcu_fd_sc_mcu7t5v0__mux2_2
XFILLER_69_2 VDD VDD VSS VSS gf180mcu_fd_sc_mcu7t5v0__fillcap_4
XTAP_TAPCELL_ROW_57_1029 VDD VSS gf180mcu_fd_sc_mcu7t5v0__filltie
XFILLER_87_928 VDD VDD VSS VSS gf180mcu_fd_sc_mcu7t5v0__fillcap_4
XTAP_TAPCELL_ROW_130_1982 VDD VSS gf180mcu_fd_sc_mcu7t5v0__filltie
XTAP_TAPCELL_ROW_130_1971 VDD VSS gf180mcu_fd_sc_mcu7t5v0__filltie
X_3235_ _3986_/Q _4129_/D _3236_/B VDD VDD VSS VSS gf180mcu_fd_sc_mcu7t5v0__nand2_1
XFILLER_58_107 VDD VDD VSS VSS gf180mcu_fd_sc_mcu7t5v0__fillcap_4
XFILLER_58_129 VDD VDD VSS VSS gf180mcu_fd_sc_mcu7t5v0__fillcap_32
XFILLER_104_27 VDD VDD VSS VSS gf180mcu_fd_sc_mcu7t5v0__fillcap_8
XFILLER_27_527 VDD VDD VSS VSS gf180mcu_fd_sc_mcu7t5v0__fill_2
XFILLER_66_162 VDD VDD VSS VSS gf180mcu_fd_sc_mcu7t5v0__fillcap_8
X_2117_ _2109_/I _2117_/A2 _2123_/B2 VDD VDD VSS VSS gf180mcu_fd_sc_mcu7t5v0__nor2_1
XFILLER_67_696 VDD VDD VSS VSS gf180mcu_fd_sc_mcu7t5v0__fillcap_4
X_2048_ place71/Z _2097_/A2 _2097_/A3 _2047_/Z _2050_/A2 VDD VDD VSS VSS gf180mcu_fd_sc_mcu7t5v0__nand4_2
XTAP_TAPCELL_ROW_68_1169 VDD VSS gf180mcu_fd_sc_mcu7t5v0__filltie
XFILLER_120_37 VDD VDD VSS VSS gf180mcu_fd_sc_mcu7t5v0__fillcap_32
XTAP_TAPCELL_ROW_81_1336 VDD VSS gf180mcu_fd_sc_mcu7t5v0__filltie
XFILLER_23_755 VDD VDD VSS VSS gf180mcu_fd_sc_mcu7t5v0__fillcap_8
X_3999_ _3999_/D _4148_/RN _4028_/CLK _3999_/Q VDD VDD VSS VSS gf180mcu_fd_sc_mcu7t5v0__dffrnq_1
XFILLER_11_928 VDD VDD VSS VSS gf180mcu_fd_sc_mcu7t5v0__fillcap_4
XFILLER_129_68 VDD VDD VSS VSS gf180mcu_fd_sc_mcu7t5v0__fill_2
XFILLER_116_381 VDD VDD VSS VSS gf180mcu_fd_sc_mcu7t5v0__fillcap_4
XFILLER_132_874 VDD VDD VSS VSS gf180mcu_fd_sc_mcu7t5v0__fill_1
XTAP_TAPCELL_ROW_92_1487 VDD VSS gf180mcu_fd_sc_mcu7t5v0__filltie
XTAP_TAPCELL_ROW_92_1476 VDD VSS gf180mcu_fd_sc_mcu7t5v0__filltie
XFILLER_89_232 VDD VDD VSS VSS gf180mcu_fd_sc_mcu7t5v0__fillcap_32
XFILLER_1_136 VDD VDD VSS VSS gf180mcu_fd_sc_mcu7t5v0__fillcap_4
XFILLER_38_76 VDD VDD VSS VSS gf180mcu_fd_sc_mcu7t5v0__fill_2
XFILLER_18_527 VDD VDD VSS VSS gf180mcu_fd_sc_mcu7t5v0__fillcap_32
XFILLER_45_346 VDD VDD VSS VSS gf180mcu_fd_sc_mcu7t5v0__fillcap_4
XFILLER_45_368 VDD VDD VSS VSS gf180mcu_fd_sc_mcu7t5v0__fillcap_8
XFILLER_61_839 VDD VDD VSS VSS gf180mcu_fd_sc_mcu7t5v0__fill_1
XFILLER_26_593 VDD VDD VSS VSS gf180mcu_fd_sc_mcu7t5v0__fill_2
XFILLER_60_349 VDD VDD VSS VSS gf180mcu_fd_sc_mcu7t5v0__fillcap_16
XTAP_TAPCELL_ROW_101_1594 VDD VSS gf180mcu_fd_sc_mcu7t5v0__filltie
XFILLER_126_101 VDD VDD VSS VSS gf180mcu_fd_sc_mcu7t5v0__fillcap_4
XTAP_TAPCELL_ROW_11_433 VDD VSS gf180mcu_fd_sc_mcu7t5v0__filltie
Xclkload17 _4153_/CLK clkload17/ZN VDD VDD VSS VSS gf180mcu_fd_sc_mcu7t5v0__clkinv_1
XFILLER_70_85 VDD VDD VSS VSS gf180mcu_fd_sc_mcu7t5v0__fillcap_16
Xclkload39 _3729_/CLK clkload39/ZN VDD VDD VSS VSS gf180mcu_fd_sc_mcu7t5v0__clkinv_1
Xclkload28 _4115_/CLK clkload28/Z VDD VDD VSS VSS gf180mcu_fd_sc_mcu7t5v0__clkbuf_2
XFILLER_79_72 VDD VDD VSS VSS gf180mcu_fd_sc_mcu7t5v0__fillcap_8
XFILLER_69_928 VDD VDD VSS VSS gf180mcu_fd_sc_mcu7t5v0__fillcap_4
XFILLER_110_513 VDD VDD VSS VSS gf180mcu_fd_sc_mcu7t5v0__fillcap_8
XFILLER_122_395 VDD VDD VSS VSS gf180mcu_fd_sc_mcu7t5v0__fill_1
XFILLER_95_279 VDD VDD VSS VSS gf180mcu_fd_sc_mcu7t5v0__fill_1
Xclkbuf_leaf_0_clk clkbuf_leaf_5_clk/I clkload7/I VDD VDD VSS VSS gf180mcu_fd_sc_mcu7t5v0__clkbuf_8
XFILLER_49_696 VDD VDD VSS VSS gf180mcu_fd_sc_mcu7t5v0__fillcap_4
XTAP_TAPCELL_ROW_19_533 VDD VSS gf180mcu_fd_sc_mcu7t5v0__filltie
XTAP_TAPCELL_ROW_47_897 VDD VSS gf180mcu_fd_sc_mcu7t5v0__filltie
X_3922_ _3922_/D _2279_/I _4125_/CLK _3922_/Q VDD VDD VSS VSS gf180mcu_fd_sc_mcu7t5v0__dffrnq_1
XFILLER_51_349 VDD VDD VSS VSS gf180mcu_fd_sc_mcu7t5v0__fill_1
X_3853_ _3853_/D _3866_/CLK _3853_/Q VDD VDD VSS VSS gf180mcu_fd_sc_mcu7t5v0__dffq_1
XFILLER_60_861 VDD VDD VSS VSS gf180mcu_fd_sc_mcu7t5v0__fillcap_8
X_2804_ place89/Z _3854_/Q _2816_/S _3854_/D VDD VDD VSS VSS gf180mcu_fd_sc_mcu7t5v0__mux2_2
XTAP_TAPCELL_ROW_63_1099 VDD VSS gf180mcu_fd_sc_mcu7t5v0__filltie
XTAP_TAPCELL_ROW_119_1833 VDD VSS gf180mcu_fd_sc_mcu7t5v0__filltie
X_3784_ _3784_/D _3864_/CLK _3784_/Q VDD VDD VSS VSS gf180mcu_fd_sc_mcu7t5v0__dffq_1
X_2666_ place88/Z _3791_/Q _2676_/S _3791_/D VDD VDD VSS VSS gf180mcu_fd_sc_mcu7t5v0__mux2_2
XFILLER_132_104 VDD VDD VSS VSS gf180mcu_fd_sc_mcu7t5v0__fillcap_32
XFILLER_105_329 VDD VDD VSS VSS gf180mcu_fd_sc_mcu7t5v0__fillcap_4
XFILLER_115_59 VDD VDD VSS VSS gf180mcu_fd_sc_mcu7t5v0__fillcap_8
XPHY_EDGE_ROW_19_Left_152 VDD VSS gf180mcu_fd_sc_mcu7t5v0__endcap
XFILLER_67_482 VDD VDD VSS VSS gf180mcu_fd_sc_mcu7t5v0__fillcap_8
XFILLER_54_154 VDD VDD VSS VSS gf180mcu_fd_sc_mcu7t5v0__fill_2
XFILLER_131_69 VDD VDD VSS VSS gf180mcu_fd_sc_mcu7t5v0__fill_1
XFILLER_70_669 VDD VDD VSS VSS gf180mcu_fd_sc_mcu7t5v0__fill_1
XFILLER_24_34 VDD VDD VSS VSS gf180mcu_fd_sc_mcu7t5v0__fill_1
XFILLER_50_382 VDD VDD VSS VSS gf180mcu_fd_sc_mcu7t5v0__fill_2
XFILLER_6_206 VDD VDD VSS VSS gf180mcu_fd_sc_mcu7t5v0__fillcap_32
XTAP_TAPCELL_ROW_94_1505 VDD VSS gf180mcu_fd_sc_mcu7t5v0__filltie
XPHY_EDGE_ROW_28_Left_161 VDD VSS gf180mcu_fd_sc_mcu7t5v0__endcap
XFILLER_132_682 VDD VDD VSS VSS gf180mcu_fd_sc_mcu7t5v0__fill_1
XFILLER_120_800 VDD VDD VSS VSS gf180mcu_fd_sc_mcu7t5v0__fillcap_4
XFILLER_105_885 VDD VDD VSS VSS gf180mcu_fd_sc_mcu7t5v0__fillcap_16
XFILLER_105_874 VDD VDD VSS VSS gf180mcu_fd_sc_mcu7t5v0__fill_2
XFILLER_2_489 VDD VDD VSS VSS gf180mcu_fd_sc_mcu7t5v0__fillcap_8
XFILLER_104_384 VDD VDD VSS VSS gf180mcu_fd_sc_mcu7t5v0__fill_1
XFILLER_66_909 VDD VDD VSS VSS gf180mcu_fd_sc_mcu7t5v0__fillcap_16
XFILLER_120_877 VDD VDD VSS VSS gf180mcu_fd_sc_mcu7t5v0__fillcap_16
XFILLER_77_279 VDD VDD VSS VSS gf180mcu_fd_sc_mcu7t5v0__fill_1
XFILLER_77_257 VDD VDD VSS VSS gf180mcu_fd_sc_mcu7t5v0__fillcap_16
XPHY_EDGE_ROW_37_Left_170 VDD VSS gf180mcu_fd_sc_mcu7t5v0__endcap
XFILLER_92_227 VDD VDD VSS VSS gf180mcu_fd_sc_mcu7t5v0__fillcap_16
XFILLER_19_836 VDD VDD VSS VSS gf180mcu_fd_sc_mcu7t5v0__fillcap_4
XFILLER_45_154 VDD VDD VSS VSS gf180mcu_fd_sc_mcu7t5v0__fill_2
XFILLER_65_52 VDD VDD VSS VSS gf180mcu_fd_sc_mcu7t5v0__fill_2
XFILLER_33_305 VDD VDD VSS VSS gf180mcu_fd_sc_mcu7t5v0__fillcap_4
XFILLER_34_839 VDD VDD VSS VSS gf180mcu_fd_sc_mcu7t5v0__fillcap_16
XTAP_TAPCELL_ROW_103_1623 VDD VSS gf180mcu_fd_sc_mcu7t5v0__filltie
XTAP_TAPCELL_ROW_44_856 VDD VSS gf180mcu_fd_sc_mcu7t5v0__filltie
XFILLER_81_62 VDD VDD VSS VSS gf180mcu_fd_sc_mcu7t5v0__fillcap_8
XFILLER_42_872 VDD VDD VSS VSS gf180mcu_fd_sc_mcu7t5v0__fill_2
XFILLER_128_933 VDD VDD VSS VSS gf180mcu_fd_sc_mcu7t5v0__fill_1
XTAP_TAPCELL_ROW_132_2019 VDD VSS gf180mcu_fd_sc_mcu7t5v0__filltie
XTAP_TAPCELL_ROW_132_2008 VDD VSS gf180mcu_fd_sc_mcu7t5v0__filltie
XFILLER_127_454 VDD VDD VSS VSS gf180mcu_fd_sc_mcu7t5v0__fillcap_16
X_2451_ _3413_/A1 _3414_/A1 _2523_/A3 _2466_/S VDD VDD VSS VSS gf180mcu_fd_sc_mcu7t5v0__nand3_2
XTAP_TAPCELL_ROW_114_1774 VDD VSS gf180mcu_fd_sc_mcu7t5v0__filltie
XTAP_TAPCELL_ROW_114_1763 VDD VSS gf180mcu_fd_sc_mcu7t5v0__filltie
XFILLER_111_822 VDD VDD VSS VSS gf180mcu_fd_sc_mcu7t5v0__fillcap_4
XFILLER_96_522 VDD VDD VSS VSS gf180mcu_fd_sc_mcu7t5v0__fill_2
XFILLER_69_714 VDD VDD VSS VSS gf180mcu_fd_sc_mcu7t5v0__fill_2
X_4121_ _4121_/D _4157_/RN _4156_/CLK _4121_/Q VDD VDD VSS VSS gf180mcu_fd_sc_mcu7t5v0__dffrnq_1
XFILLER_69_769 VDD VDD VSS VSS gf180mcu_fd_sc_mcu7t5v0__fill_1
X_4052_ _4052_/D input92/Z _4130_/CLK _4052_/Q VDD VDD VSS VSS gf180mcu_fd_sc_mcu7t5v0__dffrnq_1
XFILLER_84_728 VDD VDD VSS VSS gf180mcu_fd_sc_mcu7t5v0__fillcap_4
XFILLER_68_279 VDD VDD VSS VSS gf180mcu_fd_sc_mcu7t5v0__fillcap_8
XFILLER_110_398 VDD VDD VSS VSS gf180mcu_fd_sc_mcu7t5v0__fillcap_4
XFILLER_25_806 VDD VDD VSS VSS gf180mcu_fd_sc_mcu7t5v0__fill_1
XFILLER_36_165 VDD VDD VSS VSS gf180mcu_fd_sc_mcu7t5v0__fillcap_8
XFILLER_37_688 VDD VDD VSS VSS gf180mcu_fd_sc_mcu7t5v0__fillcap_8
XTAP_TAPCELL_ROW_65_1128 VDD VSS gf180mcu_fd_sc_mcu7t5v0__filltie
XFILLER_91_282 VDD VDD VSS VSS gf180mcu_fd_sc_mcu7t5v0__fillcap_32
X_3905_ _3905_/D _2279_/I _4114_/CLK _3905_/Q VDD VDD VSS VSS gf180mcu_fd_sc_mcu7t5v0__dffsnq_1
XFILLER_20_522 VDD VDD VSS VSS gf180mcu_fd_sc_mcu7t5v0__fill_2
X_3836_ _3836_/D _4112_/CLK _3836_/Q VDD VDD VSS VSS gf180mcu_fd_sc_mcu7t5v0__dffq_1
XFILLER_20_588 VDD VDD VSS VSS gf180mcu_fd_sc_mcu7t5v0__fill_2
X_3767_ _3767_/D _3877_/CLK _3767_/Q VDD VDD VSS VSS gf180mcu_fd_sc_mcu7t5v0__dffq_1
XFILLER_118_454 VDD VDD VSS VSS gf180mcu_fd_sc_mcu7t5v0__fill_1
X_2718_ _3815_/Q place88/Z _2728_/S _3815_/D VDD VDD VSS VSS gf180mcu_fd_sc_mcu7t5v0__mux2_2
XFILLER_105_104 VDD VDD VSS VSS gf180mcu_fd_sc_mcu7t5v0__fillcap_8
X_3698_ _3698_/D _4098_/CLK _3698_/Q VDD VDD VSS VSS gf180mcu_fd_sc_mcu7t5v0__dffq_1
XTAP_TAPCELL_ROW_76_1279 VDD VSS gf180mcu_fd_sc_mcu7t5v0__filltie
XTAP_TAPCELL_ROW_76_1268 VDD VSS gf180mcu_fd_sc_mcu7t5v0__filltie
XFILLER_120_107 VDD VDD VSS VSS gf180mcu_fd_sc_mcu7t5v0__fillcap_8
XFILLER_102_877 VDD VDD VSS VSS gf180mcu_fd_sc_mcu7t5v0__fillcap_16
XFILLER_75_717 VDD VDD VSS VSS gf180mcu_fd_sc_mcu7t5v0__fillcap_8
XFILLER_56_931 VDD VDD VSS VSS gf180mcu_fd_sc_mcu7t5v0__fill_2
XFILLER_90_709 VDD VDD VSS VSS gf180mcu_fd_sc_mcu7t5v0__fillcap_16
XFILLER_27_132 VDD VDD VSS VSS gf180mcu_fd_sc_mcu7t5v0__fillcap_8
XFILLER_83_772 VDD VDD VSS VSS gf180mcu_fd_sc_mcu7t5v0__fill_1
XFILLER_71_912 VDD VDD VSS VSS gf180mcu_fd_sc_mcu7t5v0__fillcap_16
XFILLER_35_66 VDD VDD VSS VSS gf180mcu_fd_sc_mcu7t5v0__fillcap_4
XFILLER_55_496 VDD VDD VSS VSS gf180mcu_fd_sc_mcu7t5v0__fill_2
XFILLER_24_872 VDD VDD VSS VSS gf180mcu_fd_sc_mcu7t5v0__fill_2
XTAP_TAPCELL_ROW_41_815 VDD VSS gf180mcu_fd_sc_mcu7t5v0__filltie
XFILLER_51_10 VDD VDD VSS VSS gf180mcu_fd_sc_mcu7t5v0__fillcap_4
XTAP_TAPCELL_ROW_21_561 VDD VSS gf180mcu_fd_sc_mcu7t5v0__filltie
XFILLER_125_903 VDD VDD VSS VSS gf180mcu_fd_sc_mcu7t5v0__fillcap_4
XFILLER_109_465 VDD VDD VSS VSS gf180mcu_fd_sc_mcu7t5v0__fillcap_16
XFILLER_124_457 VDD VDD VSS VSS gf180mcu_fd_sc_mcu7t5v0__fillcap_64
XFILLER_3_754 VDD VDD VSS VSS gf180mcu_fd_sc_mcu7t5v0__fill_1
XFILLER_2_242 VDD VDD VSS VSS gf180mcu_fd_sc_mcu7t5v0__fill_2
XFILLER_38_419 VDD VDD VSS VSS gf180mcu_fd_sc_mcu7t5v0__fillcap_16
XTAP_TAPCELL_ROW_49_926 VDD VSS gf180mcu_fd_sc_mcu7t5v0__filltie
XFILLER_59_780 VDD VDD VSS VSS gf180mcu_fd_sc_mcu7t5v0__fillcap_4
Xplace50 place50/I _2430_/S VDD VDD VSS VSS gf180mcu_fd_sc_mcu7t5v0__buf_8
Xplace72 _2134_/Z place72/Z VDD VDD VSS VSS gf180mcu_fd_sc_mcu7t5v0__buf_8
Xplace61 place61/I _2319_/S VDD VDD VSS VSS gf180mcu_fd_sc_mcu7t5v0__buf_8
Xplace83 _4028_/Q place83/Z VDD VDD VSS VSS gf180mcu_fd_sc_mcu7t5v0__buf_8
XFILLER_73_260 VDD VDD VSS VSS gf180mcu_fd_sc_mcu7t5v0__fillcap_8
XFILLER_19_677 VDD VDD VSS VSS gf180mcu_fd_sc_mcu7t5v0__fillcap_4
XFILLER_19_699 VDD VDD VSS VSS gf180mcu_fd_sc_mcu7t5v0__fill_1
XTAP_TAPCELL_ROW_29_661 VDD VSS gf180mcu_fd_sc_mcu7t5v0__filltie
XFILLER_46_485 VDD VDD VSS VSS gf180mcu_fd_sc_mcu7t5v0__fillcap_8
XFILLER_62_923 VDD VDD VSS VSS gf180mcu_fd_sc_mcu7t5v0__fillcap_8
XFILLER_73_282 VDD VDD VSS VSS gf180mcu_fd_sc_mcu7t5v0__fillcap_16
XFILLER_33_124 VDD VDD VSS VSS gf180mcu_fd_sc_mcu7t5v0__fillcap_16
XFILLER_15_872 VDD VDD VSS VSS gf180mcu_fd_sc_mcu7t5v0__fill_1
XFILLER_61_488 VDD VDD VSS VSS gf180mcu_fd_sc_mcu7t5v0__fill_2
X_1951_ place71/Z place52/Z _1951_/B1 _1950_/Z _4148_/D VDD VDD VSS VSS gf180mcu_fd_sc_mcu7t5v0__aoi22_4
XFILLER_30_831 VDD VDD VSS VSS gf180mcu_fd_sc_mcu7t5v0__fill_2
X_1882_ _1892_/C _4137_/Q _1883_/B2 VDD VDD VSS VSS gf180mcu_fd_sc_mcu7t5v0__nand2_1
X_3621_ _4165_/Q _3627_/I1 _3621_/S _4165_/D VDD VDD VSS VSS gf180mcu_fd_sc_mcu7t5v0__mux2_2
XFILLER_30_897 VDD VDD VSS VSS gf180mcu_fd_sc_mcu7t5v0__fill_2
XTAP_TAPCELL_ROW_60_1069 VDD VSS gf180mcu_fd_sc_mcu7t5v0__filltie
XFILLER_128_752 VDD VDD VSS VSS gf180mcu_fd_sc_mcu7t5v0__fillcap_16
X_2503_ _3724_/Q _4074_/Q _2503_/S _3724_/D VDD VDD VSS VSS gf180mcu_fd_sc_mcu7t5v0__mux2_2
XFILLER_51_2 VDD VDD VSS VSS gf180mcu_fd_sc_mcu7t5v0__fillcap_8
XFILLER_103_608 VDD VDD VSS VSS gf180mcu_fd_sc_mcu7t5v0__fill_2
X_3483_ _4153_/Q _4155_/Q _4154_/Q _4156_/Q _4100_/Q _4099_/Q _3483_/Z VDD VDD VSS
+ VSS gf180mcu_fd_sc_mcu7t5v0__mux4_1
XFILLER_102_107 VDD VDD VSS VSS gf180mcu_fd_sc_mcu7t5v0__fillcap_16
X_2434_ _3693_/Q place82/Z _2448_/S _3693_/D VDD VDD VSS VSS gf180mcu_fd_sc_mcu7t5v0__mux2_2
XFILLER_130_438 VDD VDD VSS VSS gf180mcu_fd_sc_mcu7t5v0__fill_2
XFILLER_97_842 VDD VDD VSS VSS gf180mcu_fd_sc_mcu7t5v0__fillcap_64
XFILLER_97_831 VDD VDD VSS VSS gf180mcu_fd_sc_mcu7t5v0__fillcap_8
X_2365_ _3662_/Q _4068_/Q _2377_/S _3662_/D VDD VDD VSS VSS gf180mcu_fd_sc_mcu7t5v0__mux2_2
X_4104_ _4104_/D _4157_/RN _4109_/CLK _4104_/Q VDD VDD VSS VSS gf180mcu_fd_sc_mcu7t5v0__dffrnq_1
XFILLER_69_566 VDD VDD VSS VSS gf180mcu_fd_sc_mcu7t5v0__fill_2
XFILLER_110_173 VDD VDD VSS VSS gf180mcu_fd_sc_mcu7t5v0__fill_2
X_2296_ _3635_/Q _4073_/Q _2298_/S _3635_/D VDD VDD VSS VSS gf180mcu_fd_sc_mcu7t5v0__mux2_2
XTAP_TAPCELL_ROW_127_1943 VDD VSS gf180mcu_fd_sc_mcu7t5v0__filltie
XTAP_TAPCELL_ROW_127_1932 VDD VSS gf180mcu_fd_sc_mcu7t5v0__filltie
X_4035_ _4035_/D input92/Z _4036_/CLK _4035_/Q VDD VDD VSS VSS gf180mcu_fd_sc_mcu7t5v0__dffrnq_1
XFILLER_84_558 VDD VDD VSS VSS gf180mcu_fd_sc_mcu7t5v0__fill_2
XFILLER_112_27 VDD VDD VSS VSS gf180mcu_fd_sc_mcu7t5v0__fillcap_8
XFILLER_65_772 VDD VDD VSS VSS gf180mcu_fd_sc_mcu7t5v0__fillcap_64
XFILLER_52_444 VDD VDD VSS VSS gf180mcu_fd_sc_mcu7t5v0__fill_1
XFILLER_52_488 VDD VDD VSS VSS gf180mcu_fd_sc_mcu7t5v0__fill_1
XFILLER_21_842 VDD VDD VSS VSS gf180mcu_fd_sc_mcu7t5v0__fillcap_64
X_3819_ _3819_/D _3835_/CLK _3819_/Q VDD VDD VSS VSS gf180mcu_fd_sc_mcu7t5v0__dffq_1
XFILLER_118_251 VDD VDD VSS VSS gf180mcu_fd_sc_mcu7t5v0__fill_2
XFILLER_21_35 VDD VDD VSS VSS gf180mcu_fd_sc_mcu7t5v0__fillcap_32
XFILLER_106_457 VDD VDD VSS VSS gf180mcu_fd_sc_mcu7t5v0__fillcap_16
Xoutput160 _2255_/ZN s_axi_rdata[21] VDD VDD VSS VSS gf180mcu_fd_sc_mcu7t5v0__dlyb_1
Xoutput171 _2275_/ZN s_axi_rdata[31] VDD VDD VSS VSS gf180mcu_fd_sc_mcu7t5v0__dlyb_1
XFILLER_87_330 VDD VDD VSS VSS gf180mcu_fd_sc_mcu7t5v0__fillcap_8
XPHY_EDGE_ROW_102_Right_102 VDD VSS gf180mcu_fd_sc_mcu7t5v0__endcap
XFILLER_102_663 VDD VDD VSS VSS gf180mcu_fd_sc_mcu7t5v0__fill_2
XFILLER_87_352 VDD VDD VSS VSS gf180mcu_fd_sc_mcu7t5v0__fillcap_32
XTAP_TAPCELL_ROW_7_378 VDD VSS gf180mcu_fd_sc_mcu7t5v0__filltie
XFILLER_101_162 VDD VDD VSS VSS gf180mcu_fd_sc_mcu7t5v0__fill_2
XTAP_TAPCELL_ROW_89_1437 VDD VSS gf180mcu_fd_sc_mcu7t5v0__filltie
XFILLER_46_10 VDD VDD VSS VSS gf180mcu_fd_sc_mcu7t5v0__fill_2
XFILLER_90_506 VDD VDD VSS VSS gf180mcu_fd_sc_mcu7t5v0__fillcap_16
XTAP_TAPCELL_ROW_89_1448 VDD VSS gf180mcu_fd_sc_mcu7t5v0__filltie
XFILLER_16_625 VDD VDD VSS VSS gf180mcu_fd_sc_mcu7t5v0__fill_1
XFILLER_15_135 VDD VDD VSS VSS gf180mcu_fd_sc_mcu7t5v0__fillcap_4
XTAP_TAPCELL_ROW_26_620 VDD VSS gf180mcu_fd_sc_mcu7t5v0__filltie
XFILLER_43_422 VDD VDD VSS VSS gf180mcu_fd_sc_mcu7t5v0__fillcap_64
XFILLER_55_282 VDD VDD VSS VSS gf180mcu_fd_sc_mcu7t5v0__fillcap_32
XFILLER_31_628 VDD VDD VSS VSS gf180mcu_fd_sc_mcu7t5v0__fill_2
XTAP_TAPCELL_ROW_54_984 VDD VSS gf180mcu_fd_sc_mcu7t5v0__filltie
XFILLER_12_897 VDD VDD VSS VSS gf180mcu_fd_sc_mcu7t5v0__fill_1
XFILLER_11_352 VDD VDD VSS VSS gf180mcu_fd_sc_mcu7t5v0__fill_1
XFILLER_109_262 VDD VDD VSS VSS gf180mcu_fd_sc_mcu7t5v0__fill_1
XFILLER_125_766 VDD VDD VSS VSS gf180mcu_fd_sc_mcu7t5v0__fillcap_4
XFILLER_124_232 VDD VDD VSS VSS gf180mcu_fd_sc_mcu7t5v0__fillcap_8
XFILLER_113_906 VDD VDD VSS VSS gf180mcu_fd_sc_mcu7t5v0__fillcap_4
XFILLER_113_928 VDD VDD VSS VSS gf180mcu_fd_sc_mcu7t5v0__fillcap_4
XFILLER_3_562 VDD VDD VSS VSS gf180mcu_fd_sc_mcu7t5v0__fillcap_8
XTAP_TAPCELL_ROW_111_1733 VDD VSS gf180mcu_fd_sc_mcu7t5v0__filltie
XFILLER_79_842 VDD VDD VSS VSS gf180mcu_fd_sc_mcu7t5v0__fillcap_64
XFILLER_3_584 VDD VDD VSS VSS gf180mcu_fd_sc_mcu7t5v0__fill_2
XFILLER_87_72 VDD VDD VSS VSS gf180mcu_fd_sc_mcu7t5v0__fillcap_32
X_2150_ _3390_/A1 _3394_/A3 _3375_/A3 VDD VDD VSS VSS gf180mcu_fd_sc_mcu7t5v0__nand2_1
X_2081_ place71/Z _2097_/A2 _2097_/A3 _2080_/Z _2083_/A2 VDD VDD VSS VSS gf180mcu_fd_sc_mcu7t5v0__nand4_1
XFILLER_38_238 VDD VDD VSS VSS gf180mcu_fd_sc_mcu7t5v0__fillcap_4
XFILLER_47_772 VDD VDD VSS VSS gf180mcu_fd_sc_mcu7t5v0__fillcap_64
XFILLER_62_731 VDD VDD VSS VSS gf180mcu_fd_sc_mcu7t5v0__fillcap_4
XFILLER_34_444 VDD VDD VSS VSS gf180mcu_fd_sc_mcu7t5v0__fillcap_8
XTAP_TAPCELL_ROW_122_1873 VDD VSS gf180mcu_fd_sc_mcu7t5v0__filltie
X_2983_ _3936_/Q place87/Z _3041_/S _3936_/D VDD VDD VSS VSS gf180mcu_fd_sc_mcu7t5v0__mux2_2
X_1934_ _1942_/B _1934_/I1 _3900_/Q _1934_/Z VDD VDD VSS VSS gf180mcu_fd_sc_mcu7t5v0__mux2_2
XFILLER_30_683 VDD VDD VSS VSS gf180mcu_fd_sc_mcu7t5v0__fillcap_8
X_1865_ _3886_/Q _4132_/Q _4133_/Q _1866_/B VDD VDD VSS VSS gf180mcu_fd_sc_mcu7t5v0__oai21_1
X_3604_ _4063_/Q _4064_/Q _3623_/A3 _3605_/S VDD VDD VSS VSS gf180mcu_fd_sc_mcu7t5v0__nand3_1
Xinput95 s_axi_araddr[2] _2152_/S VDD VDD VSS VSS gf180mcu_fd_sc_mcu7t5v0__dlyb_1
XFILLER_116_733 VDD VDD VSS VSS gf180mcu_fd_sc_mcu7t5v0__fill_2
XFILLER_115_265 VDD VDD VSS VSS gf180mcu_fd_sc_mcu7t5v0__fillcap_8
XTAP_TAPCELL_ROW_73_1238 VDD VSS gf180mcu_fd_sc_mcu7t5v0__filltie
X_3466_ _3463_/Z _3470_/A2 _3467_/B VDD VDD VSS VSS gf180mcu_fd_sc_mcu7t5v0__nand2_1
XFILLER_131_747 VDD VDD VSS VSS gf180mcu_fd_sc_mcu7t5v0__fillcap_4
XFILLER_69_352 VDD VDD VSS VSS gf180mcu_fd_sc_mcu7t5v0__fillcap_16
XFILLER_84_311 VDD VDD VSS VSS gf180mcu_fd_sc_mcu7t5v0__fillcap_4
XTAP_TAPCELL_ROW_4_337 VDD VSS gf180mcu_fd_sc_mcu7t5v0__filltie
X_2279_ _2279_/I _2360_/A2 VDD VDD VSS VSS gf180mcu_fd_sc_mcu7t5v0__clkinv_1
XFILLER_57_558 VDD VDD VSS VSS gf180mcu_fd_sc_mcu7t5v0__fill_2
X_4018_ _4018_/D _4148_/RN _4045_/CLK _4018_/Q VDD VDD VSS VSS gf180mcu_fd_sc_mcu7t5v0__dffrnq_1
XFILLER_26_901 VDD VDD VSS VSS gf180mcu_fd_sc_mcu7t5v0__fillcap_4
XFILLER_25_422 VDD VDD VSS VSS gf180mcu_fd_sc_mcu7t5v0__fillcap_64
XFILLER_37_282 VDD VDD VSS VSS gf180mcu_fd_sc_mcu7t5v0__fillcap_64
XFILLER_13_617 VDD VDD VSS VSS gf180mcu_fd_sc_mcu7t5v0__fill_1
XFILLER_52_241 VDD VDD VSS VSS gf180mcu_fd_sc_mcu7t5v0__fillcap_4
XTAP_TAPCELL_ROW_84_1378 VDD VSS gf180mcu_fd_sc_mcu7t5v0__filltie
XFILLER_12_127 VDD VDD VSS VSS gf180mcu_fd_sc_mcu7t5v0__fill_2
XTAP_TAPCELL_ROW_51_943 VDD VSS gf180mcu_fd_sc_mcu7t5v0__filltie
XTAP_TAPCELL_ROW_51_954 VDD VSS gf180mcu_fd_sc_mcu7t5v0__filltie
XFILLER_32_34 VDD VDD VSS VSS gf180mcu_fd_sc_mcu7t5v0__fill_1
XFILLER_20_193 VDD VDD VSS VSS gf180mcu_fd_sc_mcu7t5v0__fill_2
XFILLER_119_582 VDD VDD VSS VSS gf180mcu_fd_sc_mcu7t5v0__fill_2
XFILLER_107_788 VDD VDD VSS VSS gf180mcu_fd_sc_mcu7t5v0__fillcap_8
XFILLER_88_661 VDD VDD VSS VSS gf180mcu_fd_sc_mcu7t5v0__fillcap_4
XFILLER_76_845 VDD VDD VSS VSS gf180mcu_fd_sc_mcu7t5v0__fill_1
XFILLER_29_772 VDD VDD VSS VSS gf180mcu_fd_sc_mcu7t5v0__fillcap_4
XFILLER_44_731 VDD VDD VSS VSS gf180mcu_fd_sc_mcu7t5v0__fillcap_4
XFILLER_129_324 VDD VDD VSS VSS gf180mcu_fd_sc_mcu7t5v0__fill_2
XFILLER_129_302 VDD VDD VSS VSS gf180mcu_fd_sc_mcu7t5v0__fill_2
XFILLER_117_508 VDD VDD VSS VSS gf180mcu_fd_sc_mcu7t5v0__fillcap_8
XFILLER_12_683 VDD VDD VSS VSS gf180mcu_fd_sc_mcu7t5v0__fill_2
XFILLER_11_193 VDD VDD VSS VSS gf180mcu_fd_sc_mcu7t5v0__fillcap_16
XFILLER_7_142 VDD VDD VSS VSS gf180mcu_fd_sc_mcu7t5v0__fillcap_64
XFILLER_4_871 VDD VDD VSS VSS gf180mcu_fd_sc_mcu7t5v0__fillcap_4
X_3320_ _3319_/B _3320_/A2 _3320_/B _3323_/A2 VDD VDD VSS VSS gf180mcu_fd_sc_mcu7t5v0__oai21_1
XFILLER_113_758 VDD VDD VSS VSS gf180mcu_fd_sc_mcu7t5v0__fillcap_8
X_3251_ _4075_/Q _4077_/Q _3278_/A1 VDD VDD VSS VSS gf180mcu_fd_sc_mcu7t5v0__nand2_1
X_2202_ _3659_/Q _3667_/Q _3675_/Q _3683_/Q place79/Z place78/Z _2202_/Z VDD VDD VSS
+ VSS gf180mcu_fd_sc_mcu7t5v0__mux4_1
XFILLER_66_311 VDD VDD VSS VSS gf180mcu_fd_sc_mcu7t5v0__fillcap_4
X_2133_ _4114_/Q _2576_/A2 _2216_/B1 _2142_/A2 VDD VDD VSS VSS gf180mcu_fd_sc_mcu7t5v0__nand3_1
XFILLER_82_804 VDD VDD VSS VSS gf180mcu_fd_sc_mcu7t5v0__fill_1
XFILLER_14_2 VDD VDD VSS VSS gf180mcu_fd_sc_mcu7t5v0__fillcap_8
XTAP_TAPCELL_ROW_124_1902 VDD VSS gf180mcu_fd_sc_mcu7t5v0__filltie
XFILLER_94_664 VDD VDD VSS VSS gf180mcu_fd_sc_mcu7t5v0__fill_1
XFILLER_54_506 VDD VDD VSS VSS gf180mcu_fd_sc_mcu7t5v0__fillcap_16
X_2064_ _1901_/C _2064_/A2 _2064_/Z VDD VDD VSS VSS gf180mcu_fd_sc_mcu7t5v0__xor2_1
XFILLER_81_336 VDD VDD VSS VSS gf180mcu_fd_sc_mcu7t5v0__fillcap_8
XFILLER_34_241 VDD VDD VSS VSS gf180mcu_fd_sc_mcu7t5v0__fillcap_4
XFILLER_22_425 VDD VDD VSS VSS gf180mcu_fd_sc_mcu7t5v0__fillcap_8
X_2966_ _4049_/Q _3929_/Q _2972_/S _3929_/D VDD VDD VSS VSS gf180mcu_fd_sc_mcu7t5v0__mux2_2
X_1917_ _4141_/Q _4140_/Q _2068_/A1 VDD VDD VSS VSS gf180mcu_fd_sc_mcu7t5v0__nand2_1
X_1848_ _1901_/B _1848_/A2 _4140_/Q _4139_/Q _1916_/B1 VDD VDD VSS VSS gf180mcu_fd_sc_mcu7t5v0__aoi211_1
XFILLER_118_37 VDD VDD VSS VSS gf180mcu_fd_sc_mcu7t5v0__fillcap_16
XTAP_TAPCELL_ROW_9_407 VDD VSS gf180mcu_fd_sc_mcu7t5v0__filltie
XFILLER_103_224 VDD VDD VSS VSS gf180mcu_fd_sc_mcu7t5v0__fillcap_32
XFILLER_131_555 VDD VDD VSS VSS gf180mcu_fd_sc_mcu7t5v0__fillcap_4
X_3449_ _4103_/Q _3459_/A1 _3452_/B _3449_/B2 _3449_/C _3450_/A4 VDD VDD VSS VSS gf180mcu_fd_sc_mcu7t5v0__oai221_1
XFILLER_58_801 VDD VDD VSS VSS gf180mcu_fd_sc_mcu7t5v0__fillcap_4
XFILLER_58_823 VDD VDD VSS VSS gf180mcu_fd_sc_mcu7t5v0__fillcap_4
XTAP_TAPCELL_ROW_86_1407 VDD VSS gf180mcu_fd_sc_mcu7t5v0__filltie
XFILLER_45_506 VDD VDD VSS VSS gf180mcu_fd_sc_mcu7t5v0__fill_1
XFILLER_126_305 VDD VDD VSS VSS gf180mcu_fd_sc_mcu7t5v0__fill_1
XTAP_TAPCELL_ROW_97_1547 VDD VSS gf180mcu_fd_sc_mcu7t5v0__filltie
XFILLER_4_101 VDD VDD VSS VSS gf180mcu_fd_sc_mcu7t5v0__fillcap_4
XFILLER_4_27 VDD VDD VSS VSS gf180mcu_fd_sc_mcu7t5v0__fillcap_8
XFILLER_76_664 VDD VDD VSS VSS gf180mcu_fd_sc_mcu7t5v0__fill_1
XFILLER_90_122 VDD VDD VSS VSS gf180mcu_fd_sc_mcu7t5v0__fillcap_32
XFILLER_36_539 VDD VDD VSS VSS gf180mcu_fd_sc_mcu7t5v0__fill_1
XFILLER_63_314 VDD VDD VSS VSS gf180mcu_fd_sc_mcu7t5v0__fillcap_8
XTAP_TAPCELL_ROW_106_1665 VDD VSS gf180mcu_fd_sc_mcu7t5v0__filltie
XFILLER_90_177 VDD VDD VSS VSS gf180mcu_fd_sc_mcu7t5v0__fillcap_64
XFILLER_17_797 VDD VDD VSS VSS gf180mcu_fd_sc_mcu7t5v0__fillcap_32
XTAP_TAPCELL_ROW_34_729 VDD VSS gf180mcu_fd_sc_mcu7t5v0__filltie
XTAP_TAPCELL_ROW_14_464 VDD VSS gf180mcu_fd_sc_mcu7t5v0__filltie
XFILLER_129_132 VDD VDD VSS VSS gf180mcu_fd_sc_mcu7t5v0__fillcap_8
XFILLER_117_305 VDD VDD VSS VSS gf180mcu_fd_sc_mcu7t5v0__fillcap_32
XFILLER_117_349 VDD VDD VSS VSS gf180mcu_fd_sc_mcu7t5v0__fill_1
XFILLER_132_308 VDD VDD VSS VSS gf180mcu_fd_sc_mcu7t5v0__fillcap_32
XFILLER_113_544 VDD VDD VSS VSS gf180mcu_fd_sc_mcu7t5v0__fill_1
XFILLER_99_789 VDD VDD VSS VSS gf180mcu_fd_sc_mcu7t5v0__fill_1
X_3303_ place81/Z _4164_/Q _4157_/D _4070_/D VDD VDD VSS VSS gf180mcu_fd_sc_mcu7t5v0__mux2_2
XTAP_TAPCELL_ROW_130_1972 VDD VSS gf180mcu_fd_sc_mcu7t5v0__filltie
X_3234_ _3234_/A1 _4129_/D _3234_/B _4055_/D VDD VDD VSS VSS gf180mcu_fd_sc_mcu7t5v0__oai21_1
XFILLER_55_804 VDD VDD VSS VSS gf180mcu_fd_sc_mcu7t5v0__fillcap_8
X_2116_ input97/Z _4124_/Q _2116_/B _2117_/A2 VDD VDD VSS VSS gf180mcu_fd_sc_mcu7t5v0__aoi21_1
XFILLER_54_314 VDD VDD VSS VSS gf180mcu_fd_sc_mcu7t5v0__fill_1
X_3096_ _3989_/Q _3096_/I1 _3160_/S _3989_/D VDD VDD VSS VSS gf180mcu_fd_sc_mcu7t5v0__mux2_2
XFILLER_66_196 VDD VDD VSS VSS gf180mcu_fd_sc_mcu7t5v0__fill_1
XFILLER_66_174 VDD VDD VSS VSS gf180mcu_fd_sc_mcu7t5v0__fill_1
X_2047_ _1888_/B _2047_/A2 _2047_/Z VDD VDD VSS VSS gf180mcu_fd_sc_mcu7t5v0__xor2_1
XFILLER_82_667 VDD VDD VSS VSS gf180mcu_fd_sc_mcu7t5v0__fillcap_8
XFILLER_81_133 VDD VDD VSS VSS gf180mcu_fd_sc_mcu7t5v0__fillcap_4
XFILLER_120_27 VDD VDD VSS VSS gf180mcu_fd_sc_mcu7t5v0__fillcap_8
XTAP_TAPCELL_ROW_81_1337 VDD VSS gf180mcu_fd_sc_mcu7t5v0__filltie
XFILLER_23_734 VDD VDD VSS VSS gf180mcu_fd_sc_mcu7t5v0__fillcap_4
XFILLER_23_767 VDD VDD VSS VSS gf180mcu_fd_sc_mcu7t5v0__fill_2
XFILLER_62_380 VDD VDD VSS VSS gf180mcu_fd_sc_mcu7t5v0__fillcap_4
X_3998_ _3998_/D _4148_/RN _4136_/CLK _3998_/Q VDD VDD VSS VSS gf180mcu_fd_sc_mcu7t5v0__dffrnq_1
XFILLER_22_244 VDD VDD VSS VSS gf180mcu_fd_sc_mcu7t5v0__fill_1
XFILLER_50_575 VDD VDD VSS VSS gf180mcu_fd_sc_mcu7t5v0__fill_2
XFILLER_50_597 VDD VDD VSS VSS gf180mcu_fd_sc_mcu7t5v0__fillcap_64
XFILLER_109_839 VDD VDD VSS VSS gf180mcu_fd_sc_mcu7t5v0__fill_1
XFILLER_117_872 VDD VDD VSS VSS gf180mcu_fd_sc_mcu7t5v0__fillcap_16
XFILLER_89_222 VDD VDD VSS VSS gf180mcu_fd_sc_mcu7t5v0__fill_1
XTAP_TAPCELL_ROW_92_1488 VDD VSS gf180mcu_fd_sc_mcu7t5v0__filltie
XTAP_TAPCELL_ROW_92_1477 VDD VSS gf180mcu_fd_sc_mcu7t5v0__filltie
XFILLER_132_886 VDD VDD VSS VSS gf180mcu_fd_sc_mcu7t5v0__fillcap_4
XFILLER_131_352 VDD VDD VSS VSS gf180mcu_fd_sc_mcu7t5v0__fillcap_64
XFILLER_46_804 VDD VDD VSS VSS gf180mcu_fd_sc_mcu7t5v0__fill_1
XFILLER_45_325 VDD VDD VSS VSS gf180mcu_fd_sc_mcu7t5v0__fill_1
XFILLER_72_100 VDD VDD VSS VSS gf180mcu_fd_sc_mcu7t5v0__fillcap_4
XFILLER_54_32 VDD VDD VSS VSS gf180mcu_fd_sc_mcu7t5v0__fill_2
XFILLER_26_561 VDD VDD VSS VSS gf180mcu_fd_sc_mcu7t5v0__fillcap_32
XFILLER_54_881 VDD VDD VSS VSS gf180mcu_fd_sc_mcu7t5v0__fill_2
XFILLER_60_317 VDD VDD VSS VSS gf180mcu_fd_sc_mcu7t5v0__fillcap_32
XFILLER_72_177 VDD VDD VSS VSS gf180mcu_fd_sc_mcu7t5v0__fillcap_16
XTAP_TAPCELL_ROW_11_423 VDD VSS gf180mcu_fd_sc_mcu7t5v0__filltie
XFILLER_127_625 VDD VDD VSS VSS gf180mcu_fd_sc_mcu7t5v0__fillcap_4
XTAP_TAPCELL_ROW_101_1595 VDD VSS gf180mcu_fd_sc_mcu7t5v0__filltie
XTAP_TAPCELL_ROW_11_434 VDD VSS gf180mcu_fd_sc_mcu7t5v0__filltie
Xclkload29 _4145_/CLK clkload29/ZN VDD VDD VSS VSS gf180mcu_fd_sc_mcu7t5v0__inv_2
Xclkload18 _3835_/CLK clkload18/Z VDD VDD VSS VSS gf180mcu_fd_sc_mcu7t5v0__clkbuf_2
XFILLER_6_933 VDD VDD VSS VSS gf180mcu_fd_sc_mcu7t5v0__fill_1
XFILLER_79_84 VDD VDD VSS VSS gf180mcu_fd_sc_mcu7t5v0__fill_2
XFILLER_96_737 VDD VDD VSS VSS gf180mcu_fd_sc_mcu7t5v0__fillcap_32
XFILLER_95_269 VDD VDD VSS VSS gf180mcu_fd_sc_mcu7t5v0__fillcap_8
XFILLER_95_72 VDD VDD VSS VSS gf180mcu_fd_sc_mcu7t5v0__fillcap_32
XFILLER_76_461 VDD VDD VSS VSS gf180mcu_fd_sc_mcu7t5v0__fill_1
XFILLER_92_932 VDD VDD VSS VSS gf180mcu_fd_sc_mcu7t5v0__fill_2
XFILLER_36_314 VDD VDD VSS VSS gf180mcu_fd_sc_mcu7t5v0__fill_1
XFILLER_48_174 VDD VDD VSS VSS gf180mcu_fd_sc_mcu7t5v0__fill_1
XTAP_TAPCELL_ROW_19_534 VDD VSS gf180mcu_fd_sc_mcu7t5v0__filltie
XFILLER_52_807 VDD VDD VSS VSS gf180mcu_fd_sc_mcu7t5v0__fillcap_8
XFILLER_64_667 VDD VDD VSS VSS gf180mcu_fd_sc_mcu7t5v0__fillcap_8
XTAP_TAPCELL_ROW_47_898 VDD VSS gf180mcu_fd_sc_mcu7t5v0__filltie
X_3921_ _3921_/D _2279_/I _3978_/CLK _3921_/Q VDD VDD VSS VSS gf180mcu_fd_sc_mcu7t5v0__dffrnq_1
X_3852_ _3852_/D _4123_/CLK _3852_/Q VDD VDD VSS VSS gf180mcu_fd_sc_mcu7t5v0__dffq_1
XFILLER_60_873 VDD VDD VSS VSS gf180mcu_fd_sc_mcu7t5v0__fill_2
XFILLER_20_737 VDD VDD VSS VSS gf180mcu_fd_sc_mcu7t5v0__fillcap_64
XFILLER_32_597 VDD VDD VSS VSS gf180mcu_fd_sc_mcu7t5v0__fillcap_16
XTAP_TAPCELL_ROW_119_1834 VDD VSS gf180mcu_fd_sc_mcu7t5v0__filltie
XFILLER_118_603 VDD VDD VSS VSS gf180mcu_fd_sc_mcu7t5v0__fill_1
X_3783_ _3783_/D _3864_/CLK _3783_/Q VDD VDD VSS VSS gf180mcu_fd_sc_mcu7t5v0__dffq_1
X_2734_ _3822_/Q place89/Z _2746_/S _3822_/D VDD VDD VSS VSS gf180mcu_fd_sc_mcu7t5v0__mux2_2
X_2596_ _3763_/Q place84/Z _2598_/S _3763_/D VDD VDD VSS VSS gf180mcu_fd_sc_mcu7t5v0__mux2_2
XFILLER_132_138 VDD VDD VSS VSS gf180mcu_fd_sc_mcu7t5v0__fillcap_32
XFILLER_115_27 VDD VDD VSS VSS gf180mcu_fd_sc_mcu7t5v0__fillcap_32
XFILLER_59_406 VDD VDD VSS VSS gf180mcu_fd_sc_mcu7t5v0__fillcap_8
XFILLER_86_247 VDD VDD VSS VSS gf180mcu_fd_sc_mcu7t5v0__fillcap_16
X_3217_ _4047_/Q _4015_/Q _4129_/D _4047_/D VDD VDD VSS VSS gf180mcu_fd_sc_mcu7t5v0__mux2_2
XFILLER_28_804 VDD VDD VSS VSS gf180mcu_fd_sc_mcu7t5v0__fill_1
X_3148_ _4014_/Q _3148_/I1 _3160_/S _4014_/D VDD VDD VSS VSS gf180mcu_fd_sc_mcu7t5v0__mux2_2
XFILLER_83_932 VDD VDD VSS VSS gf180mcu_fd_sc_mcu7t5v0__fill_2
XFILLER_55_623 VDD VDD VSS VSS gf180mcu_fd_sc_mcu7t5v0__fillcap_4
XFILLER_82_442 VDD VDD VSS VSS gf180mcu_fd_sc_mcu7t5v0__fillcap_8
XFILLER_27_347 VDD VDD VSS VSS gf180mcu_fd_sc_mcu7t5v0__fill_2
XFILLER_27_369 VDD VDD VSS VSS gf180mcu_fd_sc_mcu7t5v0__fillcap_4
XFILLER_54_122 VDD VDD VSS VSS gf180mcu_fd_sc_mcu7t5v0__fillcap_32
X_3079_ _4043_/Q _3980_/Q _3081_/S _3980_/D VDD VDD VSS VSS gf180mcu_fd_sc_mcu7t5v0__mux2_2
XFILLER_42_317 VDD VDD VSS VSS gf180mcu_fd_sc_mcu7t5v0__fillcap_8
XFILLER_54_177 VDD VDD VSS VSS gf180mcu_fd_sc_mcu7t5v0__fillcap_16
XFILLER_10_203 VDD VDD VSS VSS gf180mcu_fd_sc_mcu7t5v0__fillcap_16
XFILLER_10_225 VDD VDD VSS VSS gf180mcu_fd_sc_mcu7t5v0__fill_1
XFILLER_10_247 VDD VDD VSS VSS gf180mcu_fd_sc_mcu7t5v0__fillcap_4
XTAP_TAPCELL_ROW_94_1506 VDD VSS gf180mcu_fd_sc_mcu7t5v0__filltie
XFILLER_40_34 VDD VDD VSS VSS gf180mcu_fd_sc_mcu7t5v0__fill_1
XFILLER_108_146 VDD VDD VSS VSS gf180mcu_fd_sc_mcu7t5v0__fill_2
XFILLER_40_89 VDD VDD VSS VSS gf180mcu_fd_sc_mcu7t5v0__fill_1
XFILLER_105_842 VDD VDD VSS VSS gf180mcu_fd_sc_mcu7t5v0__fillcap_32
XFILLER_2_457 VDD VDD VSS VSS gf180mcu_fd_sc_mcu7t5v0__fillcap_32
XFILLER_104_363 VDD VDD VSS VSS gf180mcu_fd_sc_mcu7t5v0__fillcap_4
XFILLER_78_737 VDD VDD VSS VSS gf180mcu_fd_sc_mcu7t5v0__fillcap_64
XFILLER_49_65 VDD VDD VSS VSS gf180mcu_fd_sc_mcu7t5v0__fillcap_4
XFILLER_18_303 VDD VDD VSS VSS gf180mcu_fd_sc_mcu7t5v0__fillcap_8
XFILLER_34_807 VDD VDD VSS VSS gf180mcu_fd_sc_mcu7t5v0__fillcap_32
XFILLER_46_667 VDD VDD VSS VSS gf180mcu_fd_sc_mcu7t5v0__fillcap_8
XFILLER_73_486 VDD VDD VSS VSS gf180mcu_fd_sc_mcu7t5v0__fillcap_4
XFILLER_60_103 VDD VDD VSS VSS gf180mcu_fd_sc_mcu7t5v0__fill_2
XTAP_TAPCELL_ROW_103_1624 VDD VSS gf180mcu_fd_sc_mcu7t5v0__filltie
XTAP_TAPCELL_ROW_44_857 VDD VSS gf180mcu_fd_sc_mcu7t5v0__filltie
XFILLER_61_659 VDD VDD VSS VSS gf180mcu_fd_sc_mcu7t5v0__fill_1
XFILLER_14_597 VDD VDD VSS VSS gf180mcu_fd_sc_mcu7t5v0__fillcap_64
XTAP_TAPCELL_ROW_24_592 VDD VSS gf180mcu_fd_sc_mcu7t5v0__filltie
XTAP_TAPCELL_ROW_132_2009 VDD VSS gf180mcu_fd_sc_mcu7t5v0__filltie
XFILLER_127_422 VDD VDD VSS VSS gf180mcu_fd_sc_mcu7t5v0__fillcap_32
XPHY_EDGE_ROW_116_Right_116 VDD VSS gf180mcu_fd_sc_mcu7t5v0__endcap
X_2450_ _4098_/Q _3414_/A1 VDD VDD VSS VSS gf180mcu_fd_sc_mcu7t5v0__clkinv_1
XTAP_TAPCELL_ROW_114_1764 VDD VSS gf180mcu_fd_sc_mcu7t5v0__filltie
X_2381_ _3669_/Q place82/Z _2395_/S _3669_/D VDD VDD VSS VSS gf180mcu_fd_sc_mcu7t5v0__mux2_2
XFILLER_122_171 VDD VDD VSS VSS gf180mcu_fd_sc_mcu7t5v0__fillcap_4
X_4120_ _4120_/D _4157_/RN _4148_/CLK _4120_/Q VDD VDD VSS VSS gf180mcu_fd_sc_mcu7t5v0__dffrnq_1
XFILLER_68_247 VDD VDD VSS VSS gf180mcu_fd_sc_mcu7t5v0__fillcap_32
X_4051_ _4051_/D _4148_/RN _4147_/CLK _4051_/Q VDD VDD VSS VSS gf180mcu_fd_sc_mcu7t5v0__dffrnq_1
X_3002_ _3945_/Q _4033_/Q _3041_/S _3945_/D VDD VDD VSS VSS gf180mcu_fd_sc_mcu7t5v0__mux2_2
XFILLER_83_228 VDD VDD VSS VSS gf180mcu_fd_sc_mcu7t5v0__fill_2
XFILLER_65_932 VDD VDD VSS VSS gf180mcu_fd_sc_mcu7t5v0__fill_2
XFILLER_24_317 VDD VDD VSS VSS gf180mcu_fd_sc_mcu7t5v0__fillcap_64
XFILLER_36_177 VDD VDD VSS VSS gf180mcu_fd_sc_mcu7t5v0__fillcap_16
XTAP_TAPCELL_ROW_65_1129 VDD VSS gf180mcu_fd_sc_mcu7t5v0__filltie
XFILLER_51_136 VDD VDD VSS VSS gf180mcu_fd_sc_mcu7t5v0__fillcap_4
X_3904_ _3904_/D _4157_/RN _4148_/CLK _3904_/Q VDD VDD VSS VSS gf180mcu_fd_sc_mcu7t5v0__dffsnq_1
XFILLER_32_383 VDD VDD VSS VSS gf180mcu_fd_sc_mcu7t5v0__fill_2
XFILLER_119_912 VDD VDD VSS VSS gf180mcu_fd_sc_mcu7t5v0__fillcap_16
X_3835_ _3835_/D _3835_/CLK _3835_/Q VDD VDD VSS VSS gf180mcu_fd_sc_mcu7t5v0__dffq_1
XFILLER_20_556 VDD VDD VSS VSS gf180mcu_fd_sc_mcu7t5v0__fillcap_32
X_3766_ _3766_/D _4028_/CLK _3766_/Q VDD VDD VSS VSS gf180mcu_fd_sc_mcu7t5v0__dffq_1
XFILLER_118_444 VDD VDD VSS VSS gf180mcu_fd_sc_mcu7t5v0__fillcap_8
XFILLER_118_477 VDD VDD VSS VSS gf180mcu_fd_sc_mcu7t5v0__fill_2
XFILLER_106_617 VDD VDD VSS VSS gf180mcu_fd_sc_mcu7t5v0__fillcap_16
XFILLER_105_116 VDD VDD VSS VSS gf180mcu_fd_sc_mcu7t5v0__fill_2
XFILLER_10_37 VDD VDD VSS VSS gf180mcu_fd_sc_mcu7t5v0__fillcap_64
X_3697_ _3697_/D _3729_/CLK _3697_/Q VDD VDD VSS VSS gf180mcu_fd_sc_mcu7t5v0__dffq_1
XFILLER_126_37 VDD VDD VSS VSS gf180mcu_fd_sc_mcu7t5v0__fillcap_64
XFILLER_105_138 VDD VDD VSS VSS gf180mcu_fd_sc_mcu7t5v0__fill_2
XTAP_TAPCELL_ROW_76_1269 VDD VSS gf180mcu_fd_sc_mcu7t5v0__filltie
X_2648_ place88/Z _3783_/Q _2658_/S _3783_/D VDD VDD VSS VSS gf180mcu_fd_sc_mcu7t5v0__mux2_2
XFILLER_102_801 VDD VDD VSS VSS gf180mcu_fd_sc_mcu7t5v0__fillcap_4
XFILLER_0_928 VDD VDD VSS VSS gf180mcu_fd_sc_mcu7t5v0__fillcap_4
XFILLER_19_57 VDD VDD VSS VSS gf180mcu_fd_sc_mcu7t5v0__fillcap_8
XFILLER_83_740 VDD VDD VSS VSS gf180mcu_fd_sc_mcu7t5v0__fill_1
XFILLER_16_807 VDD VDD VSS VSS gf180mcu_fd_sc_mcu7t5v0__fillcap_8
XFILLER_28_667 VDD VDD VSS VSS gf180mcu_fd_sc_mcu7t5v0__fill_1
XTAP_TAPCELL_ROW_41_816 VDD VSS gf180mcu_fd_sc_mcu7t5v0__filltie
XFILLER_70_478 VDD VDD VSS VSS gf180mcu_fd_sc_mcu7t5v0__fill_1
XFILLER_51_692 VDD VDD VSS VSS gf180mcu_fd_sc_mcu7t5v0__fillcap_8
XFILLER_11_556 VDD VDD VSS VSS gf180mcu_fd_sc_mcu7t5v0__fillcap_4
XFILLER_109_433 VDD VDD VSS VSS gf180mcu_fd_sc_mcu7t5v0__fillcap_32
XFILLER_109_422 VDD VDD VSS VSS gf180mcu_fd_sc_mcu7t5v0__fill_2
XTAP_TAPCELL_ROW_21_562 VDD VSS gf180mcu_fd_sc_mcu7t5v0__filltie
XFILLER_51_66 VDD VDD VSS VSS gf180mcu_fd_sc_mcu7t5v0__fillcap_4
XFILLER_120_697 VDD VDD VSS VSS gf180mcu_fd_sc_mcu7t5v0__fillcap_4
XFILLER_19_623 VDD VDD VSS VSS gf180mcu_fd_sc_mcu7t5v0__fillcap_4
XFILLER_47_932 VDD VDD VSS VSS gf180mcu_fd_sc_mcu7t5v0__fill_2
XTAP_TAPCELL_ROW_49_927 VDD VSS gf180mcu_fd_sc_mcu7t5v0__filltie
XFILLER_93_548 VDD VDD VSS VSS gf180mcu_fd_sc_mcu7t5v0__fillcap_8
Xplace73 _3249_/B _4129_/D VDD VDD VSS VSS gf180mcu_fd_sc_mcu7t5v0__buf_8
Xplace62 place62/I _2298_/S VDD VDD VSS VSS gf180mcu_fd_sc_mcu7t5v0__buf_8
Xplace84 _4027_/Q place84/Z VDD VDD VSS VSS gf180mcu_fd_sc_mcu7t5v0__buf_8
Xplace51 place51/I _2377_/S VDD VDD VSS VSS gf180mcu_fd_sc_mcu7t5v0__buf_8
XFILLER_18_177 VDD VDD VSS VSS gf180mcu_fd_sc_mcu7t5v0__fillcap_64
XTAP_TAPCELL_ROW_29_662 VDD VSS gf180mcu_fd_sc_mcu7t5v0__filltie
XFILLER_46_497 VDD VDD VSS VSS gf180mcu_fd_sc_mcu7t5v0__fill_2
XPHY_EDGE_ROW_1_Left_134 VDD VSS gf180mcu_fd_sc_mcu7t5v0__endcap
XFILLER_61_456 VDD VDD VSS VSS gf180mcu_fd_sc_mcu7t5v0__fillcap_16
X_1950_ place71/Z _2097_/A2 _2097_/A3 _1950_/Z VDD VDD VSS VSS gf180mcu_fd_sc_mcu7t5v0__and3_4
XFILLER_119_208 VDD VDD VSS VSS gf180mcu_fd_sc_mcu7t5v0__fill_2
X_1881_ _2881_/A1 _1881_/A2 _4135_/Q _1883_/B1 VDD VDD VSS VSS gf180mcu_fd_sc_mcu7t5v0__oai21_1
XFILLER_30_865 VDD VDD VSS VSS gf180mcu_fd_sc_mcu7t5v0__fillcap_8
X_3620_ _4063_/Q _3626_/A2 _3607_/Z _3621_/S VDD VDD VSS VSS gf180mcu_fd_sc_mcu7t5v0__nor3_1
X_3551_ _3549_/Z _4149_/Q _3600_/S _4149_/D VDD VDD VSS VSS gf180mcu_fd_sc_mcu7t5v0__mux2_2
XFILLER_116_926 VDD VDD VSS VSS gf180mcu_fd_sc_mcu7t5v0__fillcap_8
XFILLER_115_436 VDD VDD VSS VSS gf180mcu_fd_sc_mcu7t5v0__fill_1
XFILLER_6_593 VDD VDD VSS VSS gf180mcu_fd_sc_mcu7t5v0__fill_2
X_3482_ _4149_/Q _4151_/Q _4150_/Q _4152_/Q _4100_/Q _4099_/Q _3482_/Z VDD VDD VSS
+ VSS gf180mcu_fd_sc_mcu7t5v0__mux4_1
XFILLER_44_2 VDD VDD VSS VSS gf180mcu_fd_sc_mcu7t5v0__fillcap_8
X_4103_ _4103_/D _4157_/RN _4109_/CLK _4103_/Q VDD VDD VSS VSS gf180mcu_fd_sc_mcu7t5v0__dffrnq_1
XFILLER_111_697 VDD VDD VSS VSS gf180mcu_fd_sc_mcu7t5v0__fill_2
X_4034_ _4034_/D _4148_/RN _4146_/CLK _4034_/Q VDD VDD VSS VSS gf180mcu_fd_sc_mcu7t5v0__dffrnq_1
XTAP_TAPCELL_ROW_127_1933 VDD VSS gf180mcu_fd_sc_mcu7t5v0__filltie
XFILLER_37_442 VDD VDD VSS VSS gf180mcu_fd_sc_mcu7t5v0__fill_1
XFILLER_25_604 VDD VDD VSS VSS gf180mcu_fd_sc_mcu7t5v0__fillcap_16
XFILLER_92_592 VDD VDD VSS VSS gf180mcu_fd_sc_mcu7t5v0__fill_2
XFILLER_24_103 VDD VDD VSS VSS gf180mcu_fd_sc_mcu7t5v0__fill_2
XFILLER_52_434 VDD VDD VSS VSS gf180mcu_fd_sc_mcu7t5v0__fillcap_8
XPHY_EDGE_ROW_56_Left_189 VDD VSS gf180mcu_fd_sc_mcu7t5v0__endcap
X_3818_ _3818_/D _4076_/CLK _3818_/Q VDD VDD VSS VSS gf180mcu_fd_sc_mcu7t5v0__dffq_1
X_3749_ _3749_/D _3749_/CLK _3749_/Q VDD VDD VSS VSS gf180mcu_fd_sc_mcu7t5v0__dffq_1
XFILLER_21_69 VDD VDD VSS VSS gf180mcu_fd_sc_mcu7t5v0__fill_1
XPHY_EDGE_ROW_65_Left_198 VDD VSS gf180mcu_fd_sc_mcu7t5v0__endcap
Xoutput161 _2257_/ZN s_axi_rdata[22] VDD VDD VSS VSS gf180mcu_fd_sc_mcu7t5v0__dlyb_1
Xoutput150 _2236_/ZN s_axi_rdata[12] VDD VDD VSS VSS gf180mcu_fd_sc_mcu7t5v0__dlyb_1
Xoutput172 _2170_/ZN s_axi_rdata[3] VDD VDD VSS VSS gf180mcu_fd_sc_mcu7t5v0__dlyb_1
XFILLER_88_865 VDD VDD VSS VSS gf180mcu_fd_sc_mcu7t5v0__fillcap_8
XTAP_TAPCELL_ROW_7_379 VDD VSS gf180mcu_fd_sc_mcu7t5v0__filltie
XTAP_TAPCELL_ROW_89_1438 VDD VSS gf180mcu_fd_sc_mcu7t5v0__filltie
XFILLER_87_397 VDD VDD VSS VSS gf180mcu_fd_sc_mcu7t5v0__fillcap_16
XFILLER_29_932 VDD VDD VSS VSS gf180mcu_fd_sc_mcu7t5v0__fill_2
XTAP_TAPCELL_ROW_89_1449 VDD VSS gf180mcu_fd_sc_mcu7t5v0__filltie
XFILLER_83_570 VDD VDD VSS VSS gf180mcu_fd_sc_mcu7t5v0__fillcap_4
XFILLER_71_710 VDD VDD VSS VSS gf180mcu_fd_sc_mcu7t5v0__fillcap_4
XFILLER_43_401 VDD VDD VSS VSS gf180mcu_fd_sc_mcu7t5v0__fillcap_4
XTAP_TAPCELL_ROW_26_621 VDD VSS gf180mcu_fd_sc_mcu7t5v0__filltie
XFILLER_15_158 VDD VDD VSS VSS gf180mcu_fd_sc_mcu7t5v0__fillcap_8
XFILLER_12_821 VDD VDD VSS VSS gf180mcu_fd_sc_mcu7t5v0__fill_1
XTAP_TAPCELL_ROW_54_985 VDD VSS gf180mcu_fd_sc_mcu7t5v0__filltie
XFILLER_129_517 VDD VDD VSS VSS gf180mcu_fd_sc_mcu7t5v0__fillcap_8
XFILLER_7_27 VDD VDD VSS VSS gf180mcu_fd_sc_mcu7t5v0__fill_2
XFILLER_124_244 VDD VDD VSS VSS gf180mcu_fd_sc_mcu7t5v0__fill_1
XTAP_TAPCELL_ROW_111_1734 VDD VSS gf180mcu_fd_sc_mcu7t5v0__filltie
XTAP_TAPCELL_ROW_111_1723 VDD VSS gf180mcu_fd_sc_mcu7t5v0__filltie
XFILLER_97_139 VDD VDD VSS VSS gf180mcu_fd_sc_mcu7t5v0__fill_1
XFILLER_3_574 VDD VDD VSS VSS gf180mcu_fd_sc_mcu7t5v0__fill_2
XFILLER_39_718 VDD VDD VSS VSS gf180mcu_fd_sc_mcu7t5v0__fill_2
XFILLER_120_450 VDD VDD VSS VSS gf180mcu_fd_sc_mcu7t5v0__fillcap_4
XFILLER_38_206 VDD VDD VSS VSS gf180mcu_fd_sc_mcu7t5v0__fillcap_32
X_2080_ _1835_/B _2079_/Z _2080_/Z VDD VDD VSS VSS gf180mcu_fd_sc_mcu7t5v0__xor2_1
XFILLER_53_209 VDD VDD VSS VSS gf180mcu_fd_sc_mcu7t5v0__fill_1
XFILLER_74_592 VDD VDD VSS VSS gf180mcu_fd_sc_mcu7t5v0__fill_2
XFILLER_19_486 VDD VDD VSS VSS gf180mcu_fd_sc_mcu7t5v0__fillcap_4
XFILLER_34_412 VDD VDD VSS VSS gf180mcu_fd_sc_mcu7t5v0__fillcap_32
XFILLER_61_220 VDD VDD VSS VSS gf180mcu_fd_sc_mcu7t5v0__fillcap_4
XTAP_TAPCELL_ROW_122_1874 VDD VSS gf180mcu_fd_sc_mcu7t5v0__filltie
XFILLER_21_139 VDD VDD VSS VSS gf180mcu_fd_sc_mcu7t5v0__fill_1
X_1864_ _3887_/Q _4134_/Q _3886_/Q _3885_/Q _1866_/A2 VDD VDD VSS VSS gf180mcu_fd_sc_mcu7t5v0__aoi211_1
X_3603_ _3603_/A1 _3607_/A2 _3607_/A3 _3623_/A3 VDD VDD VSS VSS gf180mcu_fd_sc_mcu7t5v0__nor3_1
XFILLER_128_561 VDD VDD VSS VSS gf180mcu_fd_sc_mcu7t5v0__fillcap_16
Xinput96 s_axi_araddr[3] _2112_/I VDD VDD VSS VSS gf180mcu_fd_sc_mcu7t5v0__dlyb_1
XFILLER_115_233 VDD VDD VSS VSS gf180mcu_fd_sc_mcu7t5v0__fillcap_32
X_3534_ _4120_/Q _2578_/Z _4120_/D VDD VDD VSS VSS gf180mcu_fd_sc_mcu7t5v0__xor2_1
XFILLER_116_789 VDD VDD VSS VSS gf180mcu_fd_sc_mcu7t5v0__fill_1
XTAP_TAPCELL_ROW_73_1239 VDD VSS gf180mcu_fd_sc_mcu7t5v0__filltie
X_3465_ _4105_/Q _3464_/Z _3470_/A2 VDD VDD VSS VSS gf180mcu_fd_sc_mcu7t5v0__nor2_1
XFILLER_115_277 VDD VDD VSS VSS gf180mcu_fd_sc_mcu7t5v0__fill_2
X_2416_ _3685_/Q place82/Z _2430_/S _3685_/D VDD VDD VSS VSS gf180mcu_fd_sc_mcu7t5v0__mux2_2
XFILLER_130_247 VDD VDD VSS VSS gf180mcu_fd_sc_mcu7t5v0__fillcap_64
X_3396_ place79/Z _3372_/Z _4091_/D VDD VDD VSS VSS gf180mcu_fd_sc_mcu7t5v0__xor2_1
XFILLER_111_461 VDD VDD VSS VSS gf180mcu_fd_sc_mcu7t5v0__fillcap_16
XFILLER_96_161 VDD VDD VSS VSS gf180mcu_fd_sc_mcu7t5v0__fill_1
XTAP_TAPCELL_ROW_4_338 VDD VSS gf180mcu_fd_sc_mcu7t5v0__filltie
X_2347_ _3655_/Q _4069_/Q _2357_/S _3655_/D VDD VDD VSS VSS gf180mcu_fd_sc_mcu7t5v0__mux2_2
X_2278_ _4089_/Q _3394_/A3 _2278_/B _3407_/A2 VDD VDD VSS VSS gf180mcu_fd_sc_mcu7t5v0__aoi21_2
X_4017_ _4017_/D input92/Z _4045_/CLK _4017_/Q VDD VDD VSS VSS gf180mcu_fd_sc_mcu7t5v0__dffrnq_1
XFILLER_53_765 VDD VDD VSS VSS gf180mcu_fd_sc_mcu7t5v0__fillcap_4
XTAP_TAPCELL_ROW_84_1379 VDD VSS gf180mcu_fd_sc_mcu7t5v0__filltie
XTAP_TAPCELL_ROW_51_944 VDD VSS gf180mcu_fd_sc_mcu7t5v0__filltie
XTAP_TAPCELL_ROW_51_955 VDD VSS gf180mcu_fd_sc_mcu7t5v0__filltie
XFILLER_20_172 VDD VDD VSS VSS gf180mcu_fd_sc_mcu7t5v0__fill_2
XPHY_EDGE_ROW_73_Left_206 VDD VSS gf180mcu_fd_sc_mcu7t5v0__endcap
XTAP_TAPCELL_ROW_31_690 VDD VSS gf180mcu_fd_sc_mcu7t5v0__filltie
XFILLER_107_734 VDD VDD VSS VSS gf180mcu_fd_sc_mcu7t5v0__fillcap_16
XFILLER_106_222 VDD VDD VSS VSS gf180mcu_fd_sc_mcu7t5v0__fillcap_16
XFILLER_106_244 VDD VDD VSS VSS gf180mcu_fd_sc_mcu7t5v0__fill_1
XFILLER_122_737 VDD VDD VSS VSS gf180mcu_fd_sc_mcu7t5v0__fillcap_64
XFILLER_79_139 VDD VDD VSS VSS gf180mcu_fd_sc_mcu7t5v0__fill_1
XFILLER_87_150 VDD VDD VSS VSS gf180mcu_fd_sc_mcu7t5v0__fillcap_4
XFILLER_48_504 VDD VDD VSS VSS gf180mcu_fd_sc_mcu7t5v0__fillcap_16
XPHY_EDGE_ROW_82_Left_215 VDD VSS gf180mcu_fd_sc_mcu7t5v0__endcap
XFILLER_35_209 VDD VDD VSS VSS gf180mcu_fd_sc_mcu7t5v0__fill_1
XFILLER_90_337 VDD VDD VSS VSS gf180mcu_fd_sc_mcu7t5v0__fill_1
XFILLER_56_592 VDD VDD VSS VSS gf180mcu_fd_sc_mcu7t5v0__fill_2
XTAP_TAPCELL_ROW_39_790 VDD VSS gf180mcu_fd_sc_mcu7t5v0__filltie
XFILLER_43_220 VDD VDD VSS VSS gf180mcu_fd_sc_mcu7t5v0__fillcap_4
XFILLER_71_562 VDD VDD VSS VSS gf180mcu_fd_sc_mcu7t5v0__fillcap_8
XFILLER_32_927 VDD VDD VSS VSS gf180mcu_fd_sc_mcu7t5v0__fillcap_4
XFILLER_12_662 VDD VDD VSS VSS gf180mcu_fd_sc_mcu7t5v0__fill_2
XPHY_EDGE_ROW_91_Left_224 VDD VSS gf180mcu_fd_sc_mcu7t5v0__endcap
XFILLER_11_161 VDD VDD VSS VSS gf180mcu_fd_sc_mcu7t5v0__fillcap_32
XTAP_TAPCELL_ROW_59_1050 VDD VSS gf180mcu_fd_sc_mcu7t5v0__filltie
XFILLER_99_905 VDD VDD VSS VSS gf180mcu_fd_sc_mcu7t5v0__fillcap_4
XFILLER_113_726 VDD VDD VSS VSS gf180mcu_fd_sc_mcu7t5v0__fillcap_4
XFILLER_3_371 VDD VDD VSS VSS gf180mcu_fd_sc_mcu7t5v0__fillcap_4
XFILLER_112_247 VDD VDD VSS VSS gf180mcu_fd_sc_mcu7t5v0__fillcap_8
X_3250_ _4079_/Q _3349_/A1 VDD VDD VSS VSS gf180mcu_fd_sc_mcu7t5v0__clkinv_1
X_3181_ _4030_/Q _3998_/Q _4129_/D _4030_/D VDD VDD VSS VSS gf180mcu_fd_sc_mcu7t5v0__mux2_2
X_2201_ _3747_/Q _3755_/Q _3643_/Q _3651_/Q place79/Z place78/Z _2201_/Z VDD VDD VSS
+ VSS gf180mcu_fd_sc_mcu7t5v0__mux4_1
XFILLER_120_291 VDD VDD VSS VSS gf180mcu_fd_sc_mcu7t5v0__fill_2
X_2132_ _2112_/I _2219_/B _2216_/B1 VDD VDD VSS VSS gf180mcu_fd_sc_mcu7t5v0__nor2_1
XFILLER_39_548 VDD VDD VSS VSS gf180mcu_fd_sc_mcu7t5v0__fillcap_4
XFILLER_93_142 VDD VDD VSS VSS gf180mcu_fd_sc_mcu7t5v0__fillcap_8
XFILLER_26_209 VDD VDD VSS VSS gf180mcu_fd_sc_mcu7t5v0__fillcap_4
XTAP_TAPCELL_ROW_124_1903 VDD VSS gf180mcu_fd_sc_mcu7t5v0__filltie
X_2063_ _4140_/Q _2063_/A2 _2064_/A2 VDD VDD VSS VSS gf180mcu_fd_sc_mcu7t5v0__nand2_1
XFILLER_93_186 VDD VDD VSS VSS gf180mcu_fd_sc_mcu7t5v0__fillcap_16
XFILLER_81_348 VDD VDD VSS VSS gf180mcu_fd_sc_mcu7t5v0__fill_2
XFILLER_35_765 VDD VDD VSS VSS gf180mcu_fd_sc_mcu7t5v0__fill_1
XFILLER_22_437 VDD VDD VSS VSS gf180mcu_fd_sc_mcu7t5v0__fill_2
X_2896_ _3896_/Q _4032_/Q _2900_/S _3896_/D VDD VDD VSS VSS gf180mcu_fd_sc_mcu7t5v0__mux2_2
X_1916_ _3893_/Q _1901_/B _1916_/B1 _1901_/C _3894_/Q _1931_/A1 VDD VDD VSS VSS gf180mcu_fd_sc_mcu7t5v0__oai221_1
XFILLER_129_881 VDD VDD VSS VSS gf180mcu_fd_sc_mcu7t5v0__fillcap_4
X_1847_ _1846_/Z _1822_/Z _3892_/Q _1848_/A2 VDD VDD VSS VSS gf180mcu_fd_sc_mcu7t5v0__oai21_1
XTAP_TAPCELL_ROW_9_408 VDD VSS gf180mcu_fd_sc_mcu7t5v0__filltie
X_3517_ _4114_/Q _3517_/A2 _4114_/D VDD VDD VSS VSS gf180mcu_fd_sc_mcu7t5v0__xor2_2
XFILLER_131_512 VDD VDD VSS VSS gf180mcu_fd_sc_mcu7t5v0__fill_2
XFILLER_116_597 VDD VDD VSS VSS gf180mcu_fd_sc_mcu7t5v0__fillcap_64
XFILLER_104_737 VDD VDD VSS VSS gf180mcu_fd_sc_mcu7t5v0__fillcap_8
X_3448_ _4103_/Q _3906_/Q _3449_/B2 VDD VDD VSS VSS gf180mcu_fd_sc_mcu7t5v0__nand2_1
X_3379_ _4086_/Q _3379_/A2 _4086_/D VDD VDD VSS VSS gf180mcu_fd_sc_mcu7t5v0__xor2_1
XFILLER_100_932 VDD VDD VSS VSS gf180mcu_fd_sc_mcu7t5v0__fill_2
XFILLER_97_492 VDD VDD VSS VSS gf180mcu_fd_sc_mcu7t5v0__fillcap_32
XFILLER_85_632 VDD VDD VSS VSS gf180mcu_fd_sc_mcu7t5v0__fillcap_16
XFILLER_58_868 VDD VDD VSS VSS gf180mcu_fd_sc_mcu7t5v0__fillcap_4
XFILLER_58_857 VDD VDD VSS VSS gf180mcu_fd_sc_mcu7t5v0__fillcap_4
XTAP_TAPCELL_ROW_86_1408 VDD VSS gf180mcu_fd_sc_mcu7t5v0__filltie
XFILLER_27_68 VDD VDD VSS VSS gf180mcu_fd_sc_mcu7t5v0__fill_2
XTAP_TAPCELL_ROW_36_760 VDD VSS gf180mcu_fd_sc_mcu7t5v0__filltie
XFILLER_40_201 VDD VDD VSS VSS gf180mcu_fd_sc_mcu7t5v0__fillcap_4
XFILLER_41_702 VDD VDD VSS VSS gf180mcu_fd_sc_mcu7t5v0__fillcap_64
XFILLER_53_562 VDD VDD VSS VSS gf180mcu_fd_sc_mcu7t5v0__fillcap_16
XFILLER_13_426 VDD VDD VSS VSS gf180mcu_fd_sc_mcu7t5v0__fill_2
XFILLER_40_267 VDD VDD VSS VSS gf180mcu_fd_sc_mcu7t5v0__fill_2
XFILLER_127_818 VDD VDD VSS VSS gf180mcu_fd_sc_mcu7t5v0__fillcap_16
XFILLER_126_317 VDD VDD VSS VSS gf180mcu_fd_sc_mcu7t5v0__fillcap_64
XTAP_TAPCELL_ROW_97_1548 VDD VSS gf180mcu_fd_sc_mcu7t5v0__filltie
XFILLER_111_2 VDD VDD VSS VSS gf180mcu_fd_sc_mcu7t5v0__fillcap_4
XFILLER_5_669 VDD VDD VSS VSS gf180mcu_fd_sc_mcu7t5v0__fillcap_16
XFILLER_107_586 VDD VDD VSS VSS gf180mcu_fd_sc_mcu7t5v0__fill_2
XFILLER_1_842 VDD VDD VSS VSS gf180mcu_fd_sc_mcu7t5v0__fillcap_64
XFILLER_110_718 VDD VDD VSS VSS gf180mcu_fd_sc_mcu7t5v0__fill_2
XFILLER_48_301 VDD VDD VSS VSS gf180mcu_fd_sc_mcu7t5v0__fillcap_8
XFILLER_76_621 VDD VDD VSS VSS gf180mcu_fd_sc_mcu7t5v0__fill_2
XFILLER_75_142 VDD VDD VSS VSS gf180mcu_fd_sc_mcu7t5v0__fill_1
XFILLER_29_570 VDD VDD VSS VSS gf180mcu_fd_sc_mcu7t5v0__fill_1
XFILLER_57_890 VDD VDD VSS VSS gf180mcu_fd_sc_mcu7t5v0__fillcap_16
XFILLER_63_326 VDD VDD VSS VSS gf180mcu_fd_sc_mcu7t5v0__fill_2
XFILLER_84_96 VDD VDD VSS VSS gf180mcu_fd_sc_mcu7t5v0__fillcap_8
XFILLER_17_765 VDD VDD VSS VSS gf180mcu_fd_sc_mcu7t5v0__fillcap_4
XFILLER_16_220 VDD VDD VSS VSS gf180mcu_fd_sc_mcu7t5v0__fillcap_16
XTAP_TAPCELL_ROW_106_1666 VDD VSS gf180mcu_fd_sc_mcu7t5v0__filltie
XFILLER_72_893 VDD VDD VSS VSS gf180mcu_fd_sc_mcu7t5v0__fillcap_4
XFILLER_31_212 VDD VDD VSS VSS gf180mcu_fd_sc_mcu7t5v0__fillcap_64
XTAP_TAPCELL_ROW_14_465 VDD VSS gf180mcu_fd_sc_mcu7t5v0__filltie
X_2750_ _3829_/Q place90/Z _2764_/S _3829_/D VDD VDD VSS VSS gf180mcu_fd_sc_mcu7t5v0__mux2_2
X_2681_ place89/Z _3798_/Q _2693_/S _3798_/D VDD VDD VSS VSS gf180mcu_fd_sc_mcu7t5v0__mux2_2
XFILLER_99_702 VDD VDD VSS VSS gf180mcu_fd_sc_mcu7t5v0__fillcap_8
XFILLER_113_534 VDD VDD VSS VSS gf180mcu_fd_sc_mcu7t5v0__fillcap_8
XFILLER_99_779 VDD VDD VSS VSS gf180mcu_fd_sc_mcu7t5v0__fillcap_8
XFILLER_87_908 VDD VDD VSS VSS gf180mcu_fd_sc_mcu7t5v0__fill_2
XTAP_TAPCELL_ROW_130_1973 VDD VSS gf180mcu_fd_sc_mcu7t5v0__filltie
XFILLER_100_217 VDD VDD VSS VSS gf180mcu_fd_sc_mcu7t5v0__fill_1
X_3233_ _3985_/Q _4129_/D _3234_/B VDD VDD VSS VSS gf180mcu_fd_sc_mcu7t5v0__nand2_1
XFILLER_79_492 VDD VDD VSS VSS gf180mcu_fd_sc_mcu7t5v0__fillcap_64
XFILLER_67_632 VDD VDD VSS VSS gf180mcu_fd_sc_mcu7t5v0__fillcap_64
XFILLER_27_507 VDD VDD VSS VSS gf180mcu_fd_sc_mcu7t5v0__fillcap_16
XFILLER_55_816 VDD VDD VSS VSS gf180mcu_fd_sc_mcu7t5v0__fill_1
X_3164_ _4022_/Q _3990_/Q _4129_/D _4022_/D VDD VDD VSS VSS gf180mcu_fd_sc_mcu7t5v0__mux2_2
XFILLER_94_495 VDD VDD VSS VSS gf180mcu_fd_sc_mcu7t5v0__fillcap_16
X_2115_ input97/Z _3495_/B _2116_/B VDD VDD VSS VSS gf180mcu_fd_sc_mcu7t5v0__nor2_1
XFILLER_82_646 VDD VDD VSS VSS gf180mcu_fd_sc_mcu7t5v0__fill_1
XFILLER_82_613 VDD VDD VSS VSS gf180mcu_fd_sc_mcu7t5v0__fillcap_4
XFILLER_81_112 VDD VDD VSS VSS gf180mcu_fd_sc_mcu7t5v0__fillcap_4
XFILLER_27_529 VDD VDD VSS VSS gf180mcu_fd_sc_mcu7t5v0__fill_1
X_2046_ _4137_/Q _2051_/A3 _2047_/A2 VDD VDD VSS VSS gf180mcu_fd_sc_mcu7t5v0__nand2_1
XFILLER_23_702 VDD VDD VSS VSS gf180mcu_fd_sc_mcu7t5v0__fillcap_32
XFILLER_35_562 VDD VDD VSS VSS gf180mcu_fd_sc_mcu7t5v0__fillcap_4
XTAP_TAPCELL_ROW_81_1338 VDD VSS gf180mcu_fd_sc_mcu7t5v0__filltie
XFILLER_50_521 VDD VDD VSS VSS gf180mcu_fd_sc_mcu7t5v0__fillcap_4
X_3997_ _3997_/D _4148_/RN _4057_/CLK _3997_/Q VDD VDD VSS VSS gf180mcu_fd_sc_mcu7t5v0__dffrnq_1
XFILLER_129_48 VDD VDD VSS VSS gf180mcu_fd_sc_mcu7t5v0__fillcap_16
XFILLER_108_317 VDD VDD VSS VSS gf180mcu_fd_sc_mcu7t5v0__fillcap_8
X_2879_ _2879_/A1 _2900_/S _2879_/B _3887_/D VDD VDD VSS VSS gf180mcu_fd_sc_mcu7t5v0__oai21_1
XFILLER_89_212 VDD VDD VSS VSS gf180mcu_fd_sc_mcu7t5v0__fillcap_8
XTAP_TAPCELL_ROW_92_1478 VDD VSS gf180mcu_fd_sc_mcu7t5v0__filltie
XFILLER_38_78 VDD VDD VSS VSS gf180mcu_fd_sc_mcu7t5v0__fill_1
XFILLER_57_142 VDD VDD VSS VSS gf180mcu_fd_sc_mcu7t5v0__fillcap_64
XFILLER_73_613 VDD VDD VSS VSS gf180mcu_fd_sc_mcu7t5v0__fillcap_16
XFILLER_61_819 VDD VDD VSS VSS gf180mcu_fd_sc_mcu7t5v0__fillcap_4
XFILLER_26_551 VDD VDD VSS VSS gf180mcu_fd_sc_mcu7t5v0__fillcap_4
XFILLER_13_212 VDD VDD VSS VSS gf180mcu_fd_sc_mcu7t5v0__fill_1
XFILLER_41_554 VDD VDD VSS VSS gf180mcu_fd_sc_mcu7t5v0__fillcap_4
XFILLER_13_278 VDD VDD VSS VSS gf180mcu_fd_sc_mcu7t5v0__fill_2
XTAP_TAPCELL_ROW_101_1596 VDD VSS gf180mcu_fd_sc_mcu7t5v0__filltie
XTAP_TAPCELL_ROW_11_435 VDD VSS gf180mcu_fd_sc_mcu7t5v0__filltie
XTAP_TAPCELL_ROW_11_424 VDD VSS gf180mcu_fd_sc_mcu7t5v0__filltie
Xclkload19 _3865_/CLK clkload19/ZN VDD VDD VSS VSS gf180mcu_fd_sc_mcu7t5v0__clkinv_2
XFILLER_5_422 VDD VDD VSS VSS gf180mcu_fd_sc_mcu7t5v0__fillcap_4
XFILLER_126_147 VDD VDD VSS VSS gf180mcu_fd_sc_mcu7t5v0__fillcap_16
XFILLER_108_873 VDD VDD VSS VSS gf180mcu_fd_sc_mcu7t5v0__fill_2
XTAP_TAPCELL_ROW_56_1020 VDD VSS gf180mcu_fd_sc_mcu7t5v0__filltie
XFILLER_49_632 VDD VDD VSS VSS gf180mcu_fd_sc_mcu7t5v0__fillcap_64
XFILLER_95_51 VDD VDD VSS VSS gf180mcu_fd_sc_mcu7t5v0__fill_1
XFILLER_36_304 VDD VDD VSS VSS gf180mcu_fd_sc_mcu7t5v0__fillcap_8
XTAP_TAPCELL_ROW_19_535 VDD VSS gf180mcu_fd_sc_mcu7t5v0__filltie
XFILLER_52_819 VDD VDD VSS VSS gf180mcu_fd_sc_mcu7t5v0__fill_2
X_3920_ _3920_/D _2279_/I _3978_/CLK _3920_/Q VDD VDD VSS VSS gf180mcu_fd_sc_mcu7t5v0__dffrnq_1
XFILLER_17_562 VDD VDD VSS VSS gf180mcu_fd_sc_mcu7t5v0__fillcap_64
XTAP_TAPCELL_ROW_47_899 VDD VSS gf180mcu_fd_sc_mcu7t5v0__filltie
XFILLER_64_679 VDD VDD VSS VSS gf180mcu_fd_sc_mcu7t5v0__fill_2
XTAP_TAPCELL_ROW_67_1160 VDD VSS gf180mcu_fd_sc_mcu7t5v0__filltie
XFILLER_32_521 VDD VDD VSS VSS gf180mcu_fd_sc_mcu7t5v0__fillcap_4
XFILLER_44_370 VDD VDD VSS VSS gf180mcu_fd_sc_mcu7t5v0__fillcap_8
X_3851_ _3851_/D _3866_/CLK _3851_/Q VDD VDD VSS VSS gf180mcu_fd_sc_mcu7t5v0__dffq_1
X_2802_ place90/Z _3853_/Q _2816_/S _3853_/D VDD VDD VSS VSS gf180mcu_fd_sc_mcu7t5v0__mux2_2
X_3782_ _3782_/D _3806_/CLK _3782_/Q VDD VDD VSS VSS gf180mcu_fd_sc_mcu7t5v0__dffq_1
XTAP_TAPCELL_ROW_119_1835 VDD VSS gf180mcu_fd_sc_mcu7t5v0__filltie
XFILLER_117_158 VDD VDD VSS VSS gf180mcu_fd_sc_mcu7t5v0__fillcap_4
X_2664_ place89/Z _3790_/Q _2676_/S _3790_/D VDD VDD VSS VSS gf180mcu_fd_sc_mcu7t5v0__mux2_2
XFILLER_59_418 VDD VDD VSS VSS gf180mcu_fd_sc_mcu7t5v0__fill_2
XFILLER_113_386 VDD VDD VSS VSS gf180mcu_fd_sc_mcu7t5v0__fillcap_32
XFILLER_86_237 VDD VDD VSS VSS gf180mcu_fd_sc_mcu7t5v0__fillcap_8
XFILLER_39_142 VDD VDD VSS VSS gf180mcu_fd_sc_mcu7t5v0__fillcap_64
XFILLER_54_101 VDD VDD VSS VSS gf180mcu_fd_sc_mcu7t5v0__fillcap_4
XFILLER_82_432 VDD VDD VSS VSS gf180mcu_fd_sc_mcu7t5v0__fill_2
XFILLER_82_454 VDD VDD VSS VSS gf180mcu_fd_sc_mcu7t5v0__fill_1
XFILLER_54_156 VDD VDD VSS VSS gf180mcu_fd_sc_mcu7t5v0__fill_1
XFILLER_70_605 VDD VDD VSS VSS gf180mcu_fd_sc_mcu7t5v0__fillcap_4
X_2029_ _4134_/Q _4133_/Q _4132_/Q _2030_/A2 VDD VDD VSS VSS gf180mcu_fd_sc_mcu7t5v0__nand3_1
XFILLER_35_392 VDD VDD VSS VSS gf180mcu_fd_sc_mcu7t5v0__fill_2
XFILLER_36_893 VDD VDD VSS VSS gf180mcu_fd_sc_mcu7t5v0__fillcap_8
XFILLER_50_351 VDD VDD VSS VSS gf180mcu_fd_sc_mcu7t5v0__fillcap_4
XFILLER_23_576 VDD VDD VSS VSS gf180mcu_fd_sc_mcu7t5v0__fill_1
XFILLER_50_384 VDD VDD VSS VSS gf180mcu_fd_sc_mcu7t5v0__fill_1
XFILLER_109_626 VDD VDD VSS VSS gf180mcu_fd_sc_mcu7t5v0__fillcap_4
XTAP_TAPCELL_ROW_94_1507 VDD VSS gf180mcu_fd_sc_mcu7t5v0__filltie
XFILLER_105_876 VDD VDD VSS VSS gf180mcu_fd_sc_mcu7t5v0__fill_1
XFILLER_105_72 VDD VDD VSS VSS gf180mcu_fd_sc_mcu7t5v0__fillcap_32
XFILLER_74_933 VDD VDD VSS VSS gf180mcu_fd_sc_mcu7t5v0__fill_1
XFILLER_58_462 VDD VDD VSS VSS gf180mcu_fd_sc_mcu7t5v0__fillcap_16
XFILLER_45_156 VDD VDD VSS VSS gf180mcu_fd_sc_mcu7t5v0__fill_1
XFILLER_46_679 VDD VDD VSS VSS gf180mcu_fd_sc_mcu7t5v0__fill_1
XTAP_TAPCELL_ROW_103_1625 VDD VSS gf180mcu_fd_sc_mcu7t5v0__filltie
XFILLER_61_649 VDD VDD VSS VSS gf180mcu_fd_sc_mcu7t5v0__fillcap_8
XFILLER_42_874 VDD VDD VSS VSS gf180mcu_fd_sc_mcu7t5v0__fill_1
XTAP_TAPCELL_ROW_44_858 VDD VSS gf180mcu_fd_sc_mcu7t5v0__filltie
XTAP_TAPCELL_ROW_24_593 VDD VSS gf180mcu_fd_sc_mcu7t5v0__filltie
XTAP_TAPCELL_ROW_62_1090 VDD VSS gf180mcu_fd_sc_mcu7t5v0__filltie
XFILLER_127_412 VDD VDD VSS VSS gf180mcu_fd_sc_mcu7t5v0__fillcap_8
XFILLER_6_720 VDD VDD VSS VSS gf180mcu_fd_sc_mcu7t5v0__fillcap_8
XTAP_TAPCELL_ROW_114_1765 VDD VSS gf180mcu_fd_sc_mcu7t5v0__filltie
XFILLER_96_502 VDD VDD VSS VSS gf180mcu_fd_sc_mcu7t5v0__fillcap_16
XFILLER_96_524 VDD VDD VSS VSS gf180mcu_fd_sc_mcu7t5v0__fill_1
X_4050_ _4050_/D _4148_/RN _4146_/CLK _4050_/Q VDD VDD VSS VSS gf180mcu_fd_sc_mcu7t5v0__dffrnq_1
XFILLER_36_101 VDD VDD VSS VSS gf180mcu_fd_sc_mcu7t5v0__fillcap_4
XFILLER_49_462 VDD VDD VSS VSS gf180mcu_fd_sc_mcu7t5v0__fillcap_16
XFILLER_92_785 VDD VDD VSS VSS gf180mcu_fd_sc_mcu7t5v0__fillcap_4
XFILLER_18_893 VDD VDD VSS VSS gf180mcu_fd_sc_mcu7t5v0__fillcap_4
XFILLER_45_690 VDD VDD VSS VSS gf180mcu_fd_sc_mcu7t5v0__fillcap_8
X_3903_ _3903_/D _2279_/I _4108_/CLK _3903_/Q VDD VDD VSS VSS gf180mcu_fd_sc_mcu7t5v0__dffrnq_1
XFILLER_20_502 VDD VDD VSS VSS gf180mcu_fd_sc_mcu7t5v0__fillcap_16
XFILLER_20_524 VDD VDD VSS VSS gf180mcu_fd_sc_mcu7t5v0__fill_1
X_3834_ _3834_/D _4153_/CLK _3834_/Q VDD VDD VSS VSS gf180mcu_fd_sc_mcu7t5v0__dffq_1
X_3765_ _3765_/D _3877_/CLK _3765_/Q VDD VDD VSS VSS gf180mcu_fd_sc_mcu7t5v0__dffq_1
XFILLER_118_434 VDD VDD VSS VSS gf180mcu_fd_sc_mcu7t5v0__fill_2
X_2716_ _3814_/Q place89/Z _2728_/S _3814_/D VDD VDD VSS VSS gf180mcu_fd_sc_mcu7t5v0__mux2_2
X_3696_ _3696_/D _3738_/CLK _3696_/Q VDD VDD VSS VSS gf180mcu_fd_sc_mcu7t5v0__dffq_1
X_2578_ _3519_/A1 _3519_/A2 _3522_/A1 _3519_/A3 _2578_/Z VDD VDD VSS VSS gf180mcu_fd_sc_mcu7t5v0__and4_2
XFILLER_99_384 VDD VDD VSS VSS gf180mcu_fd_sc_mcu7t5v0__fillcap_8
XFILLER_19_69 VDD VDD VSS VSS gf180mcu_fd_sc_mcu7t5v0__fill_1
XFILLER_56_933 VDD VDD VSS VSS gf180mcu_fd_sc_mcu7t5v0__fill_1
XFILLER_16_819 VDD VDD VSS VSS gf180mcu_fd_sc_mcu7t5v0__fill_1
XFILLER_55_454 VDD VDD VSS VSS gf180mcu_fd_sc_mcu7t5v0__fillcap_8
XFILLER_42_104 VDD VDD VSS VSS gf180mcu_fd_sc_mcu7t5v0__fill_1
XFILLER_55_498 VDD VDD VSS VSS gf180mcu_fd_sc_mcu7t5v0__fill_1
XFILLER_24_874 VDD VDD VSS VSS gf180mcu_fd_sc_mcu7t5v0__fill_1
XFILLER_70_457 VDD VDD VSS VSS gf180mcu_fd_sc_mcu7t5v0__fillcap_8
XFILLER_23_384 VDD VDD VSS VSS gf180mcu_fd_sc_mcu7t5v0__fillcap_4
XFILLER_24_896 VDD VDD VSS VSS gf180mcu_fd_sc_mcu7t5v0__fill_2
XTAP_TAPCELL_ROW_41_817 VDD VSS gf180mcu_fd_sc_mcu7t5v0__filltie
XFILLER_51_660 VDD VDD VSS VSS gf180mcu_fd_sc_mcu7t5v0__fillcap_32
Xclkbuf_3_3__f_clk clkbuf_0_clk/Z clkload2/I VDD VDD VSS VSS gf180mcu_fd_sc_mcu7t5v0__clkbuf_16
XPHY_EDGE_ROW_14_Right_14 VDD VSS gf180mcu_fd_sc_mcu7t5v0__endcap
XTAP_TAPCELL_ROW_21_563 VDD VSS gf180mcu_fd_sc_mcu7t5v0__filltie
XFILLER_109_489 VDD VDD VSS VSS gf180mcu_fd_sc_mcu7t5v0__fill_1
XFILLER_2_244 VDD VDD VSS VSS gf180mcu_fd_sc_mcu7t5v0__fill_1
XFILLER_104_150 VDD VDD VSS VSS gf180mcu_fd_sc_mcu7t5v0__fillcap_16
XPHY_EDGE_ROW_23_Right_23 VDD VSS gf180mcu_fd_sc_mcu7t5v0__endcap
XFILLER_47_900 VDD VDD VSS VSS gf180mcu_fd_sc_mcu7t5v0__fillcap_8
XTAP_TAPCELL_ROW_49_917 VDD VSS gf180mcu_fd_sc_mcu7t5v0__filltie
XTAP_TAPCELL_ROW_49_928 VDD VSS gf180mcu_fd_sc_mcu7t5v0__filltie
XFILLER_65_207 VDD VDD VSS VSS gf180mcu_fd_sc_mcu7t5v0__fill_2
XFILLER_18_101 VDD VDD VSS VSS gf180mcu_fd_sc_mcu7t5v0__fillcap_4
XFILLER_132_70 VDD VDD VSS VSS gf180mcu_fd_sc_mcu7t5v0__fillcap_8
Xplace52 place52/I place52/Z VDD VDD VSS VSS gf180mcu_fd_sc_mcu7t5v0__buf_8
Xplace63 _2177_/Z place63/Z VDD VDD VSS VSS gf180mcu_fd_sc_mcu7t5v0__buf_8
XTAP_TAPCELL_ROW_29_663 VDD VSS gf180mcu_fd_sc_mcu7t5v0__filltie
Xplace74 _4118_/Q place74/Z VDD VDD VSS VSS gf180mcu_fd_sc_mcu7t5v0__buf_8
Xplace85 _4026_/Q place85/Z VDD VDD VSS VSS gf180mcu_fd_sc_mcu7t5v0__buf_8
XPHY_EDGE_ROW_32_Right_32 VDD VSS gf180mcu_fd_sc_mcu7t5v0__endcap
X_1880_ _3889_/Q _1892_/C _4137_/Q _1883_/A2 VDD VDD VSS VSS gf180mcu_fd_sc_mcu7t5v0__nand3_1
XFILLER_30_833 VDD VDD VSS VSS gf180mcu_fd_sc_mcu7t5v0__fill_1
XFILLER_128_732 VDD VDD VSS VSS gf180mcu_fd_sc_mcu7t5v0__fill_2
XFILLER_30_877 VDD VDD VSS VSS gf180mcu_fd_sc_mcu7t5v0__fillcap_16
XFILLER_30_899 VDD VDD VSS VSS gf180mcu_fd_sc_mcu7t5v0__fill_1
X_3550_ _3901_/Q _3550_/A2 _3600_/S VDD VDD VSS VSS gf180mcu_fd_sc_mcu7t5v0__nand2_1
X_2501_ _3723_/Q _4073_/Q _2503_/S _3723_/D VDD VDD VSS VSS gf180mcu_fd_sc_mcu7t5v0__mux2_2
X_3481_ _3901_/Q _3481_/A2 _3481_/B1 _3481_/B2 _4108_/D VDD VDD VSS VSS gf180mcu_fd_sc_mcu7t5v0__aoi22_2
X_2432_ _4097_/Q _4098_/Q _2505_/A1 place58/I VDD VDD VSS VSS gf180mcu_fd_sc_mcu7t5v0__nor3_1
XPHY_EDGE_ROW_41_Right_41 VDD VSS gf180mcu_fd_sc_mcu7t5v0__endcap
XPHY_EDGE_ROW_102_Left_235 VDD VSS gf180mcu_fd_sc_mcu7t5v0__endcap
X_2363_ _3661_/Q place82/Z _2377_/S _3661_/D VDD VDD VSS VSS gf180mcu_fd_sc_mcu7t5v0__mux2_2
XFILLER_37_2 VDD VDD VSS VSS gf180mcu_fd_sc_mcu7t5v0__fillcap_4
XFILLER_123_492 VDD VDD VSS VSS gf180mcu_fd_sc_mcu7t5v0__fillcap_64
XFILLER_111_632 VDD VDD VSS VSS gf180mcu_fd_sc_mcu7t5v0__fillcap_16
X_4102_ _4102_/D _4157_/RN _4112_/CLK _4102_/Q VDD VDD VSS VSS gf180mcu_fd_sc_mcu7t5v0__dffrnq_1
XFILLER_96_387 VDD VDD VSS VSS gf180mcu_fd_sc_mcu7t5v0__fillcap_8
X_2294_ _3634_/Q place80/Z _2298_/S _3634_/D VDD VDD VSS VSS gf180mcu_fd_sc_mcu7t5v0__mux2_2
X_4033_ _4033_/D _4148_/RN _4036_/CLK _4033_/Q VDD VDD VSS VSS gf180mcu_fd_sc_mcu7t5v0__dffrnq_1
XFILLER_2_61 VDD VDD VSS VSS gf180mcu_fd_sc_mcu7t5v0__fillcap_4
XFILLER_38_933 VDD VDD VSS VSS gf180mcu_fd_sc_mcu7t5v0__fill_1
XTAP_TAPCELL_ROW_127_1934 VDD VSS gf180mcu_fd_sc_mcu7t5v0__filltie
XFILLER_80_711 VDD VDD VSS VSS gf180mcu_fd_sc_mcu7t5v0__fill_1
XFILLER_64_240 VDD VDD VSS VSS gf180mcu_fd_sc_mcu7t5v0__fillcap_4
XPHY_EDGE_ROW_50_Right_50 VDD VSS gf180mcu_fd_sc_mcu7t5v0__endcap
XPHY_EDGE_ROW_111_Left_244 VDD VSS gf180mcu_fd_sc_mcu7t5v0__endcap
XFILLER_52_457 VDD VDD VSS VSS gf180mcu_fd_sc_mcu7t5v0__fillcap_16
XFILLER_32_170 VDD VDD VSS VSS gf180mcu_fd_sc_mcu7t5v0__fillcap_4
X_3817_ _3817_/D _4153_/CLK _3817_/Q VDD VDD VSS VSS gf180mcu_fd_sc_mcu7t5v0__dffq_1
XFILLER_20_376 VDD VDD VSS VSS gf180mcu_fd_sc_mcu7t5v0__fillcap_8
XFILLER_20_387 VDD VDD VSS VSS gf180mcu_fd_sc_mcu7t5v0__fill_1
X_3748_ _3748_/D _4157_/CLK _3748_/Q VDD VDD VSS VSS gf180mcu_fd_sc_mcu7t5v0__dffq_1
XFILLER_118_253 VDD VDD VSS VSS gf180mcu_fd_sc_mcu7t5v0__fill_1
X_3679_ _3679_/D _3750_/CLK _3679_/Q VDD VDD VSS VSS gf180mcu_fd_sc_mcu7t5v0__dffq_1
Xoutput151 _2239_/ZN s_axi_rdata[13] VDD VDD VSS VSS gf180mcu_fd_sc_mcu7t5v0__dlyb_1
XPHY_EDGE_ROW_120_Left_253 VDD VSS gf180mcu_fd_sc_mcu7t5v0__endcap
XFILLER_88_811 VDD VDD VSS VSS gf180mcu_fd_sc_mcu7t5v0__fill_1
Xoutput173 _2187_/ZN s_axi_rdata[4] VDD VDD VSS VSS gf180mcu_fd_sc_mcu7t5v0__dlyb_1
Xoutput162 _2259_/ZN s_axi_rdata[23] VDD VDD VSS VSS gf180mcu_fd_sc_mcu7t5v0__dlyb_1
XFILLER_102_643 VDD VDD VSS VSS gf180mcu_fd_sc_mcu7t5v0__fillcap_16
XFILLER_88_877 VDD VDD VSS VSS gf180mcu_fd_sc_mcu7t5v0__fillcap_32
XFILLER_101_142 VDD VDD VSS VSS gf180mcu_fd_sc_mcu7t5v0__fillcap_16
XTAP_TAPCELL_ROW_89_1439 VDD VSS gf180mcu_fd_sc_mcu7t5v0__filltie
XFILLER_28_410 VDD VDD VSS VSS gf180mcu_fd_sc_mcu7t5v0__fillcap_16
XFILLER_44_925 VDD VDD VSS VSS gf180mcu_fd_sc_mcu7t5v0__fillcap_8
XFILLER_46_45 VDD VDD VSS VSS gf180mcu_fd_sc_mcu7t5v0__fillcap_4
XTAP_TAPCELL_ROW_26_622 VDD VSS gf180mcu_fd_sc_mcu7t5v0__filltie
XFILLER_46_78 VDD VDD VSS VSS gf180mcu_fd_sc_mcu7t5v0__fillcap_16
XFILLER_70_243 VDD VDD VSS VSS gf180mcu_fd_sc_mcu7t5v0__fill_2
XFILLER_102_84 VDD VDD VSS VSS gf180mcu_fd_sc_mcu7t5v0__fillcap_16
XFILLER_30_107 VDD VDD VSS VSS gf180mcu_fd_sc_mcu7t5v0__fillcap_32
XTAP_TAPCELL_ROW_54_986 VDD VSS gf180mcu_fd_sc_mcu7t5v0__filltie
Xclkbuf_leaf_50_clk clkload0/I _4156_/CLK VDD VDD VSS VSS gf180mcu_fd_sc_mcu7t5v0__clkbuf_8
XFILLER_12_877 VDD VDD VSS VSS gf180mcu_fd_sc_mcu7t5v0__fillcap_16
XFILLER_125_702 VDD VDD VSS VSS gf180mcu_fd_sc_mcu7t5v0__fillcap_64
XFILLER_124_256 VDD VDD VSS VSS gf180mcu_fd_sc_mcu7t5v0__fillcap_8
XFILLER_112_429 VDD VDD VSS VSS gf180mcu_fd_sc_mcu7t5v0__fillcap_8
XTAP_TAPCELL_ROW_111_1735 VDD VSS gf180mcu_fd_sc_mcu7t5v0__filltie
XTAP_TAPCELL_ROW_111_1724 VDD VSS gf180mcu_fd_sc_mcu7t5v0__filltie
XFILLER_120_440 VDD VDD VSS VSS gf180mcu_fd_sc_mcu7t5v0__fillcap_4
XFILLER_78_387 VDD VDD VSS VSS gf180mcu_fd_sc_mcu7t5v0__fillcap_64
XFILLER_66_516 VDD VDD VSS VSS gf180mcu_fd_sc_mcu7t5v0__fillcap_8
XFILLER_66_527 VDD VDD VSS VSS gf180mcu_fd_sc_mcu7t5v0__fillcap_16
XTAP_TAPCELL_ROW_109_1697 VDD VSS gf180mcu_fd_sc_mcu7t5v0__filltie
XFILLER_34_457 VDD VDD VSS VSS gf180mcu_fd_sc_mcu7t5v0__fillcap_16
XTAP_TAPCELL_ROW_122_1875 VDD VSS gf180mcu_fd_sc_mcu7t5v0__filltie
X_2981_ _3935_/Q place88/Z _3041_/S _3935_/D VDD VDD VSS VSS gf180mcu_fd_sc_mcu7t5v0__mux2_2
XFILLER_15_682 VDD VDD VSS VSS gf180mcu_fd_sc_mcu7t5v0__fill_1
X_1932_ _1843_/Z _2008_/A2 _2008_/A3 _1931_/Z _1951_/B1 VDD VDD VSS VSS gf180mcu_fd_sc_mcu7t5v0__nand4_1
Xclkbuf_leaf_41_clk clkload4/I _3732_/CLK VDD VDD VSS VSS gf180mcu_fd_sc_mcu7t5v0__clkbuf_8
X_1863_ _2879_/A1 _4134_/Q _4132_/Q _2875_/A1 _1863_/C _1866_/A1 VDD VDD VSS VSS gf180mcu_fd_sc_mcu7t5v0__aoi221_1
X_3602_ _4062_/Q _3603_/A1 VDD VDD VSS VSS gf180mcu_fd_sc_mcu7t5v0__clkinv_1
Xinput97 s_axi_araddr[4] input97/Z VDD VDD VSS VSS gf180mcu_fd_sc_mcu7t5v0__dlyb_1
XFILLER_115_212 VDD VDD VSS VSS gf180mcu_fd_sc_mcu7t5v0__fillcap_4
XTAP_TAPCELL_ROW_73_1229 VDD VSS gf180mcu_fd_sc_mcu7t5v0__filltie
X_3464_ _4104_/Q _3477_/A2 _3464_/Z VDD VDD VSS VSS gf180mcu_fd_sc_mcu7t5v0__xor2_1
XFILLER_88_107 VDD VDD VSS VSS gf180mcu_fd_sc_mcu7t5v0__fillcap_64
X_3395_ _3395_/A1 _3395_/A2 _4090_/D VDD VDD VSS VSS gf180mcu_fd_sc_mcu7t5v0__nand2_1
XFILLER_85_836 VDD VDD VSS VSS gf180mcu_fd_sc_mcu7t5v0__fillcap_4
XTAP_TAPCELL_ROW_4_339 VDD VSS gf180mcu_fd_sc_mcu7t5v0__filltie
X_2277_ _4157_/Q _2278_/B VDD VDD VSS VSS gf180mcu_fd_sc_mcu7t5v0__clkinv_1
XFILLER_85_869 VDD VDD VSS VSS gf180mcu_fd_sc_mcu7t5v0__fillcap_8
X_4016_ _4016_/D _4148_/RN _4136_/CLK _4016_/Q VDD VDD VSS VSS gf180mcu_fd_sc_mcu7t5v0__dffrnq_1
XFILLER_38_785 VDD VDD VSS VSS gf180mcu_fd_sc_mcu7t5v0__fill_2
XFILLER_16_37 VDD VDD VSS VSS gf180mcu_fd_sc_mcu7t5v0__fillcap_8
XFILLER_12_107 VDD VDD VSS VSS gf180mcu_fd_sc_mcu7t5v0__fillcap_16
XFILLER_41_928 VDD VDD VSS VSS gf180mcu_fd_sc_mcu7t5v0__fillcap_4
Xclkbuf_leaf_32_clk clkload6/I _3749_/CLK VDD VDD VSS VSS gf180mcu_fd_sc_mcu7t5v0__clkbuf_8
XTAP_TAPCELL_ROW_51_945 VDD VSS gf180mcu_fd_sc_mcu7t5v0__filltie
XFILLER_119_562 VDD VDD VSS VSS gf180mcu_fd_sc_mcu7t5v0__fillcap_16
XFILLER_107_702 VDD VDD VSS VSS gf180mcu_fd_sc_mcu7t5v0__fillcap_32
XTAP_TAPCELL_ROW_31_691 VDD VSS gf180mcu_fd_sc_mcu7t5v0__filltie
XFILLER_119_584 VDD VDD VSS VSS gf180mcu_fd_sc_mcu7t5v0__fill_1
XFILLER_79_129 VDD VDD VSS VSS gf180mcu_fd_sc_mcu7t5v0__fillcap_8
XFILLER_0_512 VDD VDD VSS VSS gf180mcu_fd_sc_mcu7t5v0__fillcap_32
XFILLER_130_771 VDD VDD VSS VSS gf180mcu_fd_sc_mcu7t5v0__fill_1
XFILLER_57_66 VDD VDD VSS VSS gf180mcu_fd_sc_mcu7t5v0__fillcap_4
XFILLER_75_368 VDD VDD VSS VSS gf180mcu_fd_sc_mcu7t5v0__fillcap_4
XFILLER_57_88 VDD VDD VSS VSS gf180mcu_fd_sc_mcu7t5v0__fillcap_4
XFILLER_113_72 VDD VDD VSS VSS gf180mcu_fd_sc_mcu7t5v0__fillcap_16
XFILLER_73_54 VDD VDD VSS VSS gf180mcu_fd_sc_mcu7t5v0__fillcap_16
XFILLER_16_457 VDD VDD VSS VSS gf180mcu_fd_sc_mcu7t5v0__fillcap_64
XTAP_TAPCELL_ROW_39_791 VDD VSS gf180mcu_fd_sc_mcu7t5v0__filltie
XFILLER_71_574 VDD VDD VSS VSS gf180mcu_fd_sc_mcu7t5v0__fill_1
Xclkbuf_leaf_23_clk clkload5/I _3975_/CLK VDD VDD VSS VSS gf180mcu_fd_sc_mcu7t5v0__clkbuf_8
XFILLER_129_326 VDD VDD VSS VSS gf180mcu_fd_sc_mcu7t5v0__fill_1
XFILLER_129_304 VDD VDD VSS VSS gf180mcu_fd_sc_mcu7t5v0__fill_1
XFILLER_8_667 VDD VDD VSS VSS gf180mcu_fd_sc_mcu7t5v0__fillcap_64
XFILLER_99_928 VDD VDD VSS VSS gf180mcu_fd_sc_mcu7t5v0__fillcap_4
XTAP_TAPCELL_ROW_59_1051 VDD VSS gf180mcu_fd_sc_mcu7t5v0__filltie
XFILLER_98_427 VDD VDD VSS VSS gf180mcu_fd_sc_mcu7t5v0__fillcap_16
XFILLER_112_259 VDD VDD VSS VSS gf180mcu_fd_sc_mcu7t5v0__fill_2
X_2200_ _3715_/Q _3723_/Q _3731_/Q _3739_/Q place79/Z place78/Z _2200_/Z VDD VDD VSS
+ VSS gf180mcu_fd_sc_mcu7t5v0__mux4_1
XFILLER_94_644 VDD VDD VSS VSS gf180mcu_fd_sc_mcu7t5v0__fillcap_16
XFILLER_79_696 VDD VDD VSS VSS gf180mcu_fd_sc_mcu7t5v0__fillcap_4
XFILLER_78_173 VDD VDD VSS VSS gf180mcu_fd_sc_mcu7t5v0__fill_2
X_2131_ _4110_/Q _4111_/Q _4113_/Q _4112_/Q _2576_/A2 VDD VDD VSS VSS gf180mcu_fd_sc_mcu7t5v0__nor4_2
X_2062_ _2008_/Z _2062_/A2 _2062_/B _4140_/D VDD VDD VSS VSS gf180mcu_fd_sc_mcu7t5v0__oai21_4
XTAP_TAPCELL_ROW_124_1904 VDD VSS gf180mcu_fd_sc_mcu7t5v0__filltie
XFILLER_90_872 VDD VDD VSS VSS gf180mcu_fd_sc_mcu7t5v0__fill_2
XFILLER_23_928 VDD VDD VSS VSS gf180mcu_fd_sc_mcu7t5v0__fillcap_4
XFILLER_35_788 VDD VDD VSS VSS gf180mcu_fd_sc_mcu7t5v0__fill_2
X_2964_ _4048_/Q _3928_/Q _2972_/S _3928_/D VDD VDD VSS VSS gf180mcu_fd_sc_mcu7t5v0__mux2_2
Xclkbuf_leaf_14_clk clkload1/I _4130_/CLK VDD VDD VSS VSS gf180mcu_fd_sc_mcu7t5v0__clkbuf_8
X_1915_ _1915_/A1 _1899_/Z _1915_/B _1915_/C _2008_/A3 VDD VDD VSS VSS gf180mcu_fd_sc_mcu7t5v0__oai211_2
X_2895_ _2895_/A1 _2900_/S _2895_/B _3895_/D VDD VDD VSS VSS gf180mcu_fd_sc_mcu7t5v0__oai21_1
X_1846_ _3891_/Q _3889_/Q _3890_/Q _1846_/Z VDD VDD VSS VSS gf180mcu_fd_sc_mcu7t5v0__or3_1
XTAP_TAPCELL_ROW_9_409 VDD VSS gf180mcu_fd_sc_mcu7t5v0__filltie
X_3516_ _3516_/A1 _3516_/A2 _3516_/A3 _3501_/Z _1797_/Z _3517_/A2 VDD VDD VSS VSS
+ gf180mcu_fd_sc_mcu7t5v0__oai32_1
XFILLER_104_727 VDD VDD VSS VSS gf180mcu_fd_sc_mcu7t5v0__fillcap_8
XFILLER_89_416 VDD VDD VSS VSS gf180mcu_fd_sc_mcu7t5v0__fillcap_4
XPHY_EDGE_ROW_4_Right_4 VDD VSS gf180mcu_fd_sc_mcu7t5v0__endcap
X_3447_ _3418_/Z _3447_/A2 _3443_/B _3452_/B VDD VDD VSS VSS gf180mcu_fd_sc_mcu7t5v0__nand3_1
XFILLER_131_579 VDD VDD VSS VSS gf180mcu_fd_sc_mcu7t5v0__fillcap_8
X_3378_ _4085_/Q _3376_/Z _3378_/B _3379_/A2 VDD VDD VSS VSS gf180mcu_fd_sc_mcu7t5v0__oai21_1
XTAP_TAPCELL_ROW_86_1409 VDD VSS gf180mcu_fd_sc_mcu7t5v0__filltie
XFILLER_27_36 VDD VDD VSS VSS gf180mcu_fd_sc_mcu7t5v0__fillcap_32
XFILLER_57_346 VDD VDD VSS VSS gf180mcu_fd_sc_mcu7t5v0__fillcap_4
XFILLER_57_368 VDD VDD VSS VSS gf180mcu_fd_sc_mcu7t5v0__fillcap_4
XFILLER_85_699 VDD VDD VSS VSS gf180mcu_fd_sc_mcu7t5v0__fill_1
XFILLER_38_593 VDD VDD VSS VSS gf180mcu_fd_sc_mcu7t5v0__fill_2
XFILLER_25_276 VDD VDD VSS VSS gf180mcu_fd_sc_mcu7t5v0__fillcap_4
XTAP_TAPCELL_ROW_36_750 VDD VSS gf180mcu_fd_sc_mcu7t5v0__filltie
XFILLER_80_371 VDD VDD VSS VSS gf180mcu_fd_sc_mcu7t5v0__fillcap_8
XFILLER_25_298 VDD VDD VSS VSS gf180mcu_fd_sc_mcu7t5v0__fillcap_8
XFILLER_21_471 VDD VDD VSS VSS gf180mcu_fd_sc_mcu7t5v0__fillcap_4
XTAP_TAPCELL_ROW_97_1549 VDD VSS gf180mcu_fd_sc_mcu7t5v0__filltie
XFILLER_5_637 VDD VDD VSS VSS gf180mcu_fd_sc_mcu7t5v0__fillcap_32
XFILLER_5_626 VDD VDD VSS VSS gf180mcu_fd_sc_mcu7t5v0__fillcap_4
XFILLER_96_909 VDD VDD VSS VSS gf180mcu_fd_sc_mcu7t5v0__fillcap_16
XFILLER_122_568 VDD VDD VSS VSS gf180mcu_fd_sc_mcu7t5v0__fill_1
XFILLER_95_408 VDD VDD VSS VSS gf180mcu_fd_sc_mcu7t5v0__fillcap_8
XFILLER_0_342 VDD VDD VSS VSS gf180mcu_fd_sc_mcu7t5v0__fillcap_32
XFILLER_48_313 VDD VDD VSS VSS gf180mcu_fd_sc_mcu7t5v0__fill_2
XFILLER_49_836 VDD VDD VSS VSS gf180mcu_fd_sc_mcu7t5v0__fillcap_4
XFILLER_49_858 VDD VDD VSS VSS gf180mcu_fd_sc_mcu7t5v0__fillcap_4
XFILLER_91_603 VDD VDD VSS VSS gf180mcu_fd_sc_mcu7t5v0__fillcap_16
XFILLER_63_349 VDD VDD VSS VSS gf180mcu_fd_sc_mcu7t5v0__fill_1
XTAP_TAPCELL_ROW_106_1667 VDD VSS gf180mcu_fd_sc_mcu7t5v0__filltie
XFILLER_72_861 VDD VDD VSS VSS gf180mcu_fd_sc_mcu7t5v0__fillcap_8
XFILLER_20_909 VDD VDD VSS VSS gf180mcu_fd_sc_mcu7t5v0__fillcap_16
XTAP_TAPCELL_ROW_14_466 VDD VSS gf180mcu_fd_sc_mcu7t5v0__filltie
XFILLER_12_471 VDD VDD VSS VSS gf180mcu_fd_sc_mcu7t5v0__fill_1
XFILLER_9_932 VDD VDD VSS VSS gf180mcu_fd_sc_mcu7t5v0__fill_2
XFILLER_8_453 VDD VDD VSS VSS gf180mcu_fd_sc_mcu7t5v0__fill_2
XFILLER_99_714 VDD VDD VSS VSS gf180mcu_fd_sc_mcu7t5v0__fill_1
X_3301_ _4069_/Q _4163_/Q _4157_/D _4069_/D VDD VDD VSS VSS gf180mcu_fd_sc_mcu7t5v0__mux2_2
XTAP_TAPCELL_ROW_130_1974 VDD VSS gf180mcu_fd_sc_mcu7t5v0__filltie
Xclkbuf_leaf_3_clk clkbuf_leaf_5_clk/I _4023_/CLK VDD VDD VSS VSS gf180mcu_fd_sc_mcu7t5v0__clkbuf_8
XFILLER_94_463 VDD VDD VSS VSS gf180mcu_fd_sc_mcu7t5v0__fillcap_32
XFILLER_39_346 VDD VDD VSS VSS gf180mcu_fd_sc_mcu7t5v0__fillcap_4
X_2114_ _3901_/Q _3495_/B VDD VDD VSS VSS gf180mcu_fd_sc_mcu7t5v0__clkinv_1
X_3094_ _3988_/Q _3094_/I1 _4131_/D _3988_/D VDD VDD VSS VSS gf180mcu_fd_sc_mcu7t5v0__mux2_2
X_2045_ _2008_/Z _2045_/A2 _2045_/B _4137_/D VDD VDD VSS VSS gf180mcu_fd_sc_mcu7t5v0__oai21_4
XTAP_TAPCELL_ROW_81_1339 VDD VSS gf180mcu_fd_sc_mcu7t5v0__filltie
XTAP_TAPCELL_ROW_33_720 VDD VSS gf180mcu_fd_sc_mcu7t5v0__filltie
X_3996_ _3996_/D input92/Z _4028_/CLK _3996_/Q VDD VDD VSS VSS gf180mcu_fd_sc_mcu7t5v0__dffrnq_1
XFILLER_11_909 VDD VDD VSS VSS gf180mcu_fd_sc_mcu7t5v0__fill_1
XFILLER_23_769 VDD VDD VSS VSS gf180mcu_fd_sc_mcu7t5v0__fill_1
X_2947_ _4040_/Q _3920_/Q _2972_/S _3920_/D VDD VDD VSS VSS gf180mcu_fd_sc_mcu7t5v0__mux2_2
XFILLER_31_780 VDD VDD VSS VSS gf180mcu_fd_sc_mcu7t5v0__fillcap_4
XFILLER_108_329 VDD VDD VSS VSS gf180mcu_fd_sc_mcu7t5v0__fill_2
X_2878_ place88/Z _2900_/S _2879_/B VDD VDD VSS VSS gf180mcu_fd_sc_mcu7t5v0__nand2_1
X_1829_ _3897_/Q _3898_/Q _4145_/Q _1827_/Z _1833_/B1 VDD VDD VSS VSS gf180mcu_fd_sc_mcu7t5v0__nand4_1
XFILLER_89_202 VDD VDD VSS VSS gf180mcu_fd_sc_mcu7t5v0__fillcap_8
XFILLER_104_524 VDD VDD VSS VSS gf180mcu_fd_sc_mcu7t5v0__fill_1
XTAP_TAPCELL_ROW_92_1479 VDD VSS gf180mcu_fd_sc_mcu7t5v0__filltie
XFILLER_38_68 VDD VDD VSS VSS gf180mcu_fd_sc_mcu7t5v0__fillcap_8
XPHY_EDGE_ROW_79_Right_79 VDD VSS gf180mcu_fd_sc_mcu7t5v0__endcap
XFILLER_58_699 VDD VDD VSS VSS gf180mcu_fd_sc_mcu7t5v0__fillcap_16
XFILLER_45_338 VDD VDD VSS VSS gf180mcu_fd_sc_mcu7t5v0__fillcap_8
XFILLER_41_500 VDD VDD VSS VSS gf180mcu_fd_sc_mcu7t5v0__fill_2
XFILLER_54_45 VDD VDD VSS VSS gf180mcu_fd_sc_mcu7t5v0__fill_1
XFILLER_54_34 VDD VDD VSS VSS gf180mcu_fd_sc_mcu7t5v0__fill_1
XFILLER_14_769 VDD VDD VSS VSS gf180mcu_fd_sc_mcu7t5v0__fillcap_16
XTAP_TAPCELL_ROW_101_1597 VDD VSS gf180mcu_fd_sc_mcu7t5v0__filltie
XTAP_TAPCELL_ROW_11_425 VDD VSS gf180mcu_fd_sc_mcu7t5v0__filltie
XPHY_EDGE_ROW_88_Right_88 VDD VSS gf180mcu_fd_sc_mcu7t5v0__endcap
XFILLER_5_401 VDD VDD VSS VSS gf180mcu_fd_sc_mcu7t5v0__fill_2
XFILLER_108_885 VDD VDD VSS VSS gf180mcu_fd_sc_mcu7t5v0__fillcap_4
XTAP_TAPCELL_ROW_56_1010 VDD VSS gf180mcu_fd_sc_mcu7t5v0__filltie
XFILLER_107_384 VDD VDD VSS VSS gf180mcu_fd_sc_mcu7t5v0__fillcap_16
XFILLER_79_86 VDD VDD VSS VSS gf180mcu_fd_sc_mcu7t5v0__fill_1
XFILLER_122_354 VDD VDD VSS VSS gf180mcu_fd_sc_mcu7t5v0__fillcap_4
XFILLER_122_343 VDD VDD VSS VSS gf180mcu_fd_sc_mcu7t5v0__fillcap_4
XFILLER_95_205 VDD VDD VSS VSS gf180mcu_fd_sc_mcu7t5v0__fillcap_4
XFILLER_122_387 VDD VDD VSS VSS gf180mcu_fd_sc_mcu7t5v0__fillcap_8
XFILLER_110_527 VDD VDD VSS VSS gf180mcu_fd_sc_mcu7t5v0__fillcap_64
XFILLER_89_780 VDD VDD VSS VSS gf180mcu_fd_sc_mcu7t5v0__fill_2
XFILLER_0_172 VDD VDD VSS VSS gf180mcu_fd_sc_mcu7t5v0__fillcap_32
XFILLER_49_622 VDD VDD VSS VSS gf180mcu_fd_sc_mcu7t5v0__fillcap_8
XPHY_EDGE_ROW_97_Right_97 VDD VSS gf180mcu_fd_sc_mcu7t5v0__endcap
XFILLER_37_806 VDD VDD VSS VSS gf180mcu_fd_sc_mcu7t5v0__fill_2
XFILLER_48_154 VDD VDD VSS VSS gf180mcu_fd_sc_mcu7t5v0__fillcap_16
XFILLER_91_422 VDD VDD VSS VSS gf180mcu_fd_sc_mcu7t5v0__fillcap_16
XFILLER_76_496 VDD VDD VSS VSS gf180mcu_fd_sc_mcu7t5v0__fillcap_16
XTAP_TAPCELL_ROW_19_536 VDD VSS gf180mcu_fd_sc_mcu7t5v0__filltie
XFILLER_28_90 VDD VDD VSS VSS gf180mcu_fd_sc_mcu7t5v0__fillcap_8
XFILLER_91_488 VDD VDD VSS VSS gf180mcu_fd_sc_mcu7t5v0__fill_2
XTAP_TAPCELL_ROW_67_1161 VDD VSS gf180mcu_fd_sc_mcu7t5v0__filltie
XFILLER_44_382 VDD VDD VSS VSS gf180mcu_fd_sc_mcu7t5v0__fill_2
X_3850_ _3850_/D _3866_/CLK _3850_/Q VDD VDD VSS VSS gf180mcu_fd_sc_mcu7t5v0__dffq_1
XFILLER_20_717 VDD VDD VSS VSS gf180mcu_fd_sc_mcu7t5v0__fill_2
X_3781_ _3781_/D clkload7/I _3781_/Q VDD VDD VSS VSS gf180mcu_fd_sc_mcu7t5v0__dffq_1
X_2801_ _2801_/A1 _2818_/A2 _2816_/S VDD VDD VSS VSS gf180mcu_fd_sc_mcu7t5v0__nand2_4
X_2732_ _3821_/Q place90/Z _2746_/S _3821_/D VDD VDD VSS VSS gf180mcu_fd_sc_mcu7t5v0__mux2_2
XTAP_TAPCELL_ROW_119_1836 VDD VSS gf180mcu_fd_sc_mcu7t5v0__filltie
XFILLER_118_638 VDD VDD VSS VSS gf180mcu_fd_sc_mcu7t5v0__fillcap_16
XFILLER_117_104 VDD VDD VSS VSS gf180mcu_fd_sc_mcu7t5v0__fill_2
XFILLER_126_682 VDD VDD VSS VSS gf180mcu_fd_sc_mcu7t5v0__fillcap_32
X_2594_ _3762_/Q place85/Z _2598_/S _3762_/D VDD VDD VSS VSS gf180mcu_fd_sc_mcu7t5v0__mux2_2
XFILLER_5_72 VDD VDD VSS VSS gf180mcu_fd_sc_mcu7t5v0__fillcap_32
XFILLER_114_877 VDD VDD VSS VSS gf180mcu_fd_sc_mcu7t5v0__fillcap_32
X_3215_ _4046_/Q _4014_/Q _4129_/D _4046_/D VDD VDD VSS VSS gf180mcu_fd_sc_mcu7t5v0__mux2_2
X_3146_ _4013_/Q _3146_/I1 _3160_/S _4013_/D VDD VDD VSS VSS gf180mcu_fd_sc_mcu7t5v0__mux2_2
XFILLER_95_772 VDD VDD VSS VSS gf180mcu_fd_sc_mcu7t5v0__fillcap_16
XFILLER_83_912 VDD VDD VSS VSS gf180mcu_fd_sc_mcu7t5v0__fillcap_16
XFILLER_28_828 VDD VDD VSS VSS gf180mcu_fd_sc_mcu7t5v0__fillcap_32
X_3077_ _4042_/Q _3979_/Q _3081_/S _3979_/D VDD VDD VSS VSS gf180mcu_fd_sc_mcu7t5v0__mux2_2
XFILLER_27_349 VDD VDD VSS VSS gf180mcu_fd_sc_mcu7t5v0__fill_1
X_2028_ _2008_/Z _2028_/A2 _2028_/B _4134_/D VDD VDD VSS VSS gf180mcu_fd_sc_mcu7t5v0__oai21_4
XFILLER_51_842 VDD VDD VSS VSS gf180mcu_fd_sc_mcu7t5v0__fillcap_64
XFILLER_70_639 VDD VDD VSS VSS gf180mcu_fd_sc_mcu7t5v0__fillcap_8
X_3979_ _3979_/D _2279_/I _4125_/CLK _3979_/Q VDD VDD VSS VSS gf180mcu_fd_sc_mcu7t5v0__dffrnq_1
XFILLER_108_104 VDD VDD VSS VSS gf180mcu_fd_sc_mcu7t5v0__fill_1
XFILLER_108_148 VDD VDD VSS VSS gf180mcu_fd_sc_mcu7t5v0__fill_1
XTAP_TAPCELL_ROW_94_1508 VDD VSS gf180mcu_fd_sc_mcu7t5v0__filltie
XFILLER_40_69 VDD VDD VSS VSS gf180mcu_fd_sc_mcu7t5v0__fillcap_16
XFILLER_104_310 VDD VDD VSS VSS gf180mcu_fd_sc_mcu7t5v0__fillcap_4
XFILLER_49_34 VDD VDD VSS VSS gf180mcu_fd_sc_mcu7t5v0__fillcap_4
XFILLER_104_387 VDD VDD VSS VSS gf180mcu_fd_sc_mcu7t5v0__fillcap_32
XPHY_EDGE_ROW_130_Right_130 VDD VSS gf180mcu_fd_sc_mcu7t5v0__endcap
XFILLER_58_452 VDD VDD VSS VSS gf180mcu_fd_sc_mcu7t5v0__fill_2
XFILLER_85_293 VDD VDD VSS VSS gf180mcu_fd_sc_mcu7t5v0__fillcap_16
XFILLER_73_422 VDD VDD VSS VSS gf180mcu_fd_sc_mcu7t5v0__fillcap_64
XFILLER_65_44 VDD VDD VSS VSS gf180mcu_fd_sc_mcu7t5v0__fillcap_8
XFILLER_27_850 VDD VDD VSS VSS gf180mcu_fd_sc_mcu7t5v0__fillcap_4
XTAP_TAPCELL_ROW_103_1626 VDD VSS gf180mcu_fd_sc_mcu7t5v0__filltie
XFILLER_14_522 VDD VDD VSS VSS gf180mcu_fd_sc_mcu7t5v0__fill_2
XFILLER_27_883 VDD VDD VSS VSS gf180mcu_fd_sc_mcu7t5v0__fillcap_16
XFILLER_121_72 VDD VDD VSS VSS gf180mcu_fd_sc_mcu7t5v0__fill_2
XTAP_TAPCELL_ROW_44_859 VDD VSS gf180mcu_fd_sc_mcu7t5v0__filltie
XFILLER_60_138 VDD VDD VSS VSS gf180mcu_fd_sc_mcu7t5v0__fillcap_4
XFILLER_14_588 VDD VDD VSS VSS gf180mcu_fd_sc_mcu7t5v0__fillcap_4
XFILLER_41_352 VDD VDD VSS VSS gf180mcu_fd_sc_mcu7t5v0__fillcap_16
XFILLER_14_70 VDD VDD VSS VSS gf180mcu_fd_sc_mcu7t5v0__fill_2
XTAP_TAPCELL_ROW_24_594 VDD VSS gf180mcu_fd_sc_mcu7t5v0__filltie
XTAP_TAPCELL_ROW_62_1091 VDD VSS gf180mcu_fd_sc_mcu7t5v0__filltie
XFILLER_6_732 VDD VDD VSS VSS gf180mcu_fd_sc_mcu7t5v0__fill_2
XFILLER_114_107 VDD VDD VSS VSS gf180mcu_fd_sc_mcu7t5v0__fillcap_16
XTAP_TAPCELL_ROW_114_1766 VDD VSS gf180mcu_fd_sc_mcu7t5v0__filltie
XFILLER_111_814 VDD VDD VSS VSS gf180mcu_fd_sc_mcu7t5v0__fillcap_8
XFILLER_123_696 VDD VDD VSS VSS gf180mcu_fd_sc_mcu7t5v0__fillcap_4
XFILLER_110_313 VDD VDD VSS VSS gf180mcu_fd_sc_mcu7t5v0__fill_2
XFILLER_1_470 VDD VDD VSS VSS gf180mcu_fd_sc_mcu7t5v0__fillcap_16
XFILLER_1_492 VDD VDD VSS VSS gf180mcu_fd_sc_mcu7t5v0__fillcap_8
XFILLER_49_430 VDD VDD VSS VSS gf180mcu_fd_sc_mcu7t5v0__fillcap_32
X_3000_ _3944_/Q _4032_/Q _3041_/S _3944_/D VDD VDD VSS VSS gf180mcu_fd_sc_mcu7t5v0__mux2_2
XFILLER_77_772 VDD VDD VSS VSS gf180mcu_fd_sc_mcu7t5v0__fillcap_4
XFILLER_65_912 VDD VDD VSS VSS gf180mcu_fd_sc_mcu7t5v0__fillcap_16
XFILLER_37_636 VDD VDD VSS VSS gf180mcu_fd_sc_mcu7t5v0__fill_2
XFILLER_49_496 VDD VDD VSS VSS gf180mcu_fd_sc_mcu7t5v0__fill_1
XFILLER_64_411 VDD VDD VSS VSS gf180mcu_fd_sc_mcu7t5v0__fillcap_4
XFILLER_80_926 VDD VDD VSS VSS gf180mcu_fd_sc_mcu7t5v0__fillcap_8
XFILLER_33_842 VDD VDD VSS VSS gf180mcu_fd_sc_mcu7t5v0__fillcap_16
X_3902_ _3902_/D _2279_/I _4108_/CLK _3902_/Q VDD VDD VSS VSS gf180mcu_fd_sc_mcu7t5v0__dffsnq_1
X_3833_ _3833_/D _3835_/CLK _3833_/Q VDD VDD VSS VSS gf180mcu_fd_sc_mcu7t5v0__dffq_1
XFILLER_20_547 VDD VDD VSS VSS gf180mcu_fd_sc_mcu7t5v0__fill_1
X_3764_ _3764_/D _4109_/CLK _3764_/Q VDD VDD VSS VSS gf180mcu_fd_sc_mcu7t5v0__dffq_1
XFILLER_118_457 VDD VDD VSS VSS gf180mcu_fd_sc_mcu7t5v0__fillcap_16
X_3695_ _3695_/D _3729_/CLK _3695_/Q VDD VDD VSS VSS gf180mcu_fd_sc_mcu7t5v0__dffq_1
X_2646_ place89/Z _3782_/Q _2658_/S _3782_/D VDD VDD VSS VSS gf180mcu_fd_sc_mcu7t5v0__mux2_2
XFILLER_105_118 VDD VDD VSS VSS gf180mcu_fd_sc_mcu7t5v0__fill_1
XFILLER_99_352 VDD VDD VSS VSS gf180mcu_fd_sc_mcu7t5v0__fillcap_32
X_2577_ _4055_/Q _4057_/Q _3519_/A3 VDD VDD VSS VSS gf180mcu_fd_sc_mcu7t5v0__nor2_1
XFILLER_99_396 VDD VDD VSS VSS gf180mcu_fd_sc_mcu7t5v0__fill_2
XFILLER_87_558 VDD VDD VSS VSS gf180mcu_fd_sc_mcu7t5v0__fill_2
XFILLER_19_26 VDD VDD VSS VSS gf180mcu_fd_sc_mcu7t5v0__fill_2
XFILLER_56_901 VDD VDD VSS VSS gf180mcu_fd_sc_mcu7t5v0__fill_1
XFILLER_68_761 VDD VDD VSS VSS gf180mcu_fd_sc_mcu7t5v0__fillcap_4
XFILLER_55_422 VDD VDD VSS VSS gf180mcu_fd_sc_mcu7t5v0__fillcap_32
XFILLER_67_282 VDD VDD VSS VSS gf180mcu_fd_sc_mcu7t5v0__fill_1
X_3129_ _4005_/Q _3129_/I1 _3160_/S _4005_/D VDD VDD VSS VSS gf180mcu_fd_sc_mcu7t5v0__mux2_2
XFILLER_43_628 VDD VDD VSS VSS gf180mcu_fd_sc_mcu7t5v0__fill_2
XFILLER_55_488 VDD VDD VSS VSS gf180mcu_fd_sc_mcu7t5v0__fill_2
XFILLER_70_469 VDD VDD VSS VSS gf180mcu_fd_sc_mcu7t5v0__fill_2
XFILLER_23_352 VDD VDD VSS VSS gf180mcu_fd_sc_mcu7t5v0__fillcap_32
XTAP_TAPCELL_ROW_41_818 VDD VSS gf180mcu_fd_sc_mcu7t5v0__filltie
XFILLER_50_171 VDD VDD VSS VSS gf180mcu_fd_sc_mcu7t5v0__fillcap_4
XFILLER_109_424 VDD VDD VSS VSS gf180mcu_fd_sc_mcu7t5v0__fill_1
XTAP_TAPCELL_ROW_21_553 VDD VSS gf180mcu_fd_sc_mcu7t5v0__filltie
XTAP_TAPCELL_ROW_21_564 VDD VSS gf180mcu_fd_sc_mcu7t5v0__filltie
XFILLER_125_928 VDD VDD VSS VSS gf180mcu_fd_sc_mcu7t5v0__fillcap_4
XFILLER_2_201 VDD VDD VSS VSS gf180mcu_fd_sc_mcu7t5v0__fillcap_4
XFILLER_105_641 VDD VDD VSS VSS gf180mcu_fd_sc_mcu7t5v0__fillcap_8
XFILLER_2_234 VDD VDD VSS VSS gf180mcu_fd_sc_mcu7t5v0__fillcap_8
XFILLER_132_471 VDD VDD VSS VSS gf180mcu_fd_sc_mcu7t5v0__fillcap_4
XFILLER_47_912 VDD VDD VSS VSS gf180mcu_fd_sc_mcu7t5v0__fillcap_16
XTAP_TAPCELL_ROW_49_918 VDD VSS gf180mcu_fd_sc_mcu7t5v0__filltie
XTAP_TAPCELL_ROW_49_929 VDD VSS gf180mcu_fd_sc_mcu7t5v0__filltie
XFILLER_59_772 VDD VDD VSS VSS gf180mcu_fd_sc_mcu7t5v0__fillcap_8
XFILLER_93_539 VDD VDD VSS VSS gf180mcu_fd_sc_mcu7t5v0__fill_2
XFILLER_76_98 VDD VDD VSS VSS gf180mcu_fd_sc_mcu7t5v0__fillcap_4
Xplace53 _3043_/Z _3081_/S VDD VDD VSS VSS gf180mcu_fd_sc_mcu7t5v0__buf_8
XFILLER_18_168 VDD VDD VSS VSS gf180mcu_fd_sc_mcu7t5v0__fillcap_4
XFILLER_19_669 VDD VDD VSS VSS gf180mcu_fd_sc_mcu7t5v0__fill_2
Xplace64 place64/I _4157_/D VDD VDD VSS VSS gf180mcu_fd_sc_mcu7t5v0__buf_8
XTAP_TAPCELL_ROW_29_664 VDD VSS gf180mcu_fd_sc_mcu7t5v0__filltie
Xplace75 _4117_/Q place75/Z VDD VDD VSS VSS gf180mcu_fd_sc_mcu7t5v0__buf_8
XFILLER_132_82 VDD VDD VSS VSS gf180mcu_fd_sc_mcu7t5v0__fill_1
XFILLER_92_53 VDD VDD VSS VSS gf180mcu_fd_sc_mcu7t5v0__fill_2
Xplace86 _4025_/Q place86/Z VDD VDD VSS VSS gf180mcu_fd_sc_mcu7t5v0__buf_8
XFILLER_61_414 VDD VDD VSS VSS gf180mcu_fd_sc_mcu7t5v0__fillcap_4
XFILLER_15_842 VDD VDD VSS VSS gf180mcu_fd_sc_mcu7t5v0__fillcap_16
XTAP_TAPCELL_ROW_64_1120 VDD VSS gf180mcu_fd_sc_mcu7t5v0__filltie
XFILLER_30_823 VDD VDD VSS VSS gf180mcu_fd_sc_mcu7t5v0__fillcap_8
XFILLER_115_416 VDD VDD VSS VSS gf180mcu_fd_sc_mcu7t5v0__fillcap_4
X_3480_ _4108_/Q _3481_/B2 VDD VDD VSS VSS gf180mcu_fd_sc_mcu7t5v0__clkinv_1
XFILLER_127_298 VDD VDD VSS VSS gf180mcu_fd_sc_mcu7t5v0__fill_1
XFILLER_6_573 VDD VDD VSS VSS gf180mcu_fd_sc_mcu7t5v0__fillcap_16
XTAP_TAPCELL_ROW_75_1260 VDD VSS gf180mcu_fd_sc_mcu7t5v0__filltie
XFILLER_96_333 VDD VDD VSS VSS gf180mcu_fd_sc_mcu7t5v0__fillcap_4
X_4101_ _4101_/D _4157_/RN _4112_/CLK _4101_/Q VDD VDD VSS VSS gf180mcu_fd_sc_mcu7t5v0__dffrnq_1
XFILLER_111_699 VDD VDD VSS VSS gf180mcu_fd_sc_mcu7t5v0__fill_1
XFILLER_110_165 VDD VDD VSS VSS gf180mcu_fd_sc_mcu7t5v0__fillcap_8
X_4032_ _4032_/D input92/Z _4036_/CLK _4032_/Q VDD VDD VSS VSS gf180mcu_fd_sc_mcu7t5v0__dffrnq_1
XTAP_TAPCELL_ROW_127_1935 VDD VSS gf180mcu_fd_sc_mcu7t5v0__filltie
XFILLER_96_399 VDD VDD VSS VSS gf180mcu_fd_sc_mcu7t5v0__fill_2
XFILLER_37_422 VDD VDD VSS VSS gf180mcu_fd_sc_mcu7t5v0__fillcap_16
XFILLER_49_282 VDD VDD VSS VSS gf180mcu_fd_sc_mcu7t5v0__fillcap_32
XFILLER_92_594 VDD VDD VSS VSS gf180mcu_fd_sc_mcu7t5v0__fill_1
XFILLER_25_628 VDD VDD VSS VSS gf180mcu_fd_sc_mcu7t5v0__fill_2
X_3816_ _3816_/D _3835_/CLK _3816_/Q VDD VDD VSS VSS gf180mcu_fd_sc_mcu7t5v0__dffq_1
X_3747_ _3747_/D _3755_/CLK _3747_/Q VDD VDD VSS VSS gf180mcu_fd_sc_mcu7t5v0__dffq_1
XFILLER_107_928 VDD VDD VSS VSS gf180mcu_fd_sc_mcu7t5v0__fillcap_4
X_3678_ _3678_/D _4166_/CLK _3678_/Q VDD VDD VSS VSS gf180mcu_fd_sc_mcu7t5v0__dffq_1
Xoutput152 _2241_/ZN s_axi_rdata[14] VDD VDD VSS VSS gf180mcu_fd_sc_mcu7t5v0__dlyb_1
Xoutput163 _2261_/ZN s_axi_rdata[24] VDD VDD VSS VSS gf180mcu_fd_sc_mcu7t5v0__dlyb_1
Xoutput174 _2198_/ZN s_axi_rdata[5] VDD VDD VSS VSS gf180mcu_fd_sc_mcu7t5v0__dlyb_1
XFILLER_102_611 VDD VDD VSS VSS gf180mcu_fd_sc_mcu7t5v0__fillcap_32
XFILLER_0_716 VDD VDD VSS VSS gf180mcu_fd_sc_mcu7t5v0__fillcap_32
XFILLER_29_912 VDD VDD VSS VSS gf180mcu_fd_sc_mcu7t5v0__fillcap_16
XFILLER_47_208 VDD VDD VSS VSS gf180mcu_fd_sc_mcu7t5v0__fill_2
XFILLER_101_198 VDD VDD VSS VSS gf180mcu_fd_sc_mcu7t5v0__fillcap_8
XFILLER_56_731 VDD VDD VSS VSS gf180mcu_fd_sc_mcu7t5v0__fillcap_4
XFILLER_68_591 VDD VDD VSS VSS gf180mcu_fd_sc_mcu7t5v0__fillcap_4
XFILLER_56_786 VDD VDD VSS VSS gf180mcu_fd_sc_mcu7t5v0__fillcap_16
XFILLER_102_52 VDD VDD VSS VSS gf180mcu_fd_sc_mcu7t5v0__fillcap_32
XTAP_TAPCELL_ROW_26_623 VDD VSS gf180mcu_fd_sc_mcu7t5v0__filltie
XFILLER_12_801 VDD VDD VSS VSS gf180mcu_fd_sc_mcu7t5v0__fillcap_4
XFILLER_24_650 VDD VDD VSS VSS gf180mcu_fd_sc_mcu7t5v0__fillcap_8
XTAP_TAPCELL_ROW_54_987 VDD VSS gf180mcu_fd_sc_mcu7t5v0__filltie
XFILLER_62_34 VDD VDD VSS VSS gf180mcu_fd_sc_mcu7t5v0__fill_1
XFILLER_129_508 VDD VDD VSS VSS gf180mcu_fd_sc_mcu7t5v0__fillcap_4
XFILLER_12_867 VDD VDD VSS VSS gf180mcu_fd_sc_mcu7t5v0__fillcap_8
XFILLER_11_344 VDD VDD VSS VSS gf180mcu_fd_sc_mcu7t5v0__fillcap_4
XTAP_TAPCELL_ROW_111_1725 VDD VSS gf180mcu_fd_sc_mcu7t5v0__filltie
XFILLER_94_804 VDD VDD VSS VSS gf180mcu_fd_sc_mcu7t5v0__fill_1
XTAP_TAPCELL_ROW_6_370 VDD VSS gf180mcu_fd_sc_mcu7t5v0__filltie
XFILLER_19_422 VDD VDD VSS VSS gf180mcu_fd_sc_mcu7t5v0__fillcap_64
XTAP_TAPCELL_ROW_70_1190 VDD VSS gf180mcu_fd_sc_mcu7t5v0__filltie
XTAP_TAPCELL_ROW_109_1698 VDD VSS gf180mcu_fd_sc_mcu7t5v0__filltie
XFILLER_74_594 VDD VDD VSS VSS gf180mcu_fd_sc_mcu7t5v0__fill_1
XFILLER_34_403 VDD VDD VSS VSS gf180mcu_fd_sc_mcu7t5v0__fill_1
XFILLER_15_650 VDD VDD VSS VSS gf180mcu_fd_sc_mcu7t5v0__fillcap_32
XTAP_TAPCELL_ROW_122_1876 VDD VSS gf180mcu_fd_sc_mcu7t5v0__filltie
X_1931_ _1931_/A1 _1931_/A2 _1931_/A3 _1931_/Z VDD VDD VSS VSS gf180mcu_fd_sc_mcu7t5v0__and3_2
XFILLER_14_171 VDD VDD VSS VSS gf180mcu_fd_sc_mcu7t5v0__fillcap_4
XFILLER_21_119 VDD VDD VSS VSS gf180mcu_fd_sc_mcu7t5v0__fillcap_16
X_1862_ _3886_/Q _1863_/C VDD VDD VSS VSS gf180mcu_fd_sc_mcu7t5v0__clkinv_1
XFILLER_30_664 VDD VDD VSS VSS gf180mcu_fd_sc_mcu7t5v0__fill_1
Xinput98 s_axi_araddr[5] input98/Z VDD VDD VSS VSS gf180mcu_fd_sc_mcu7t5v0__dlyb_1
XFILLER_116_725 VDD VDD VSS VSS gf180mcu_fd_sc_mcu7t5v0__fillcap_8
X_3532_ _4119_/Q _3532_/A2 _4119_/D VDD VDD VSS VSS gf180mcu_fd_sc_mcu7t5v0__xnor2_1
XFILLER_131_706 VDD VDD VSS VSS gf180mcu_fd_sc_mcu7t5v0__fill_1
XFILLER_116_769 VDD VDD VSS VSS gf180mcu_fd_sc_mcu7t5v0__fillcap_16
XFILLER_6_381 VDD VDD VSS VSS gf180mcu_fd_sc_mcu7t5v0__fillcap_4
X_3463_ _3901_/Q _3468_/A2 _3463_/Z VDD VDD VSS VSS gf180mcu_fd_sc_mcu7t5v0__and2_1
XFILLER_115_279 VDD VDD VSS VSS gf180mcu_fd_sc_mcu7t5v0__fill_1
XFILLER_103_419 VDD VDD VSS VSS gf180mcu_fd_sc_mcu7t5v0__fill_1
X_2414_ _4097_/Q _4098_/Q _2360_/Z place50/I VDD VDD VSS VSS gf180mcu_fd_sc_mcu7t5v0__nor3_1
XFILLER_130_238 VDD VDD VSS VSS gf180mcu_fd_sc_mcu7t5v0__fillcap_4
X_3394_ _4089_/Q _4157_/Q _3394_/A3 _3394_/A4 _3395_/A2 VDD VDD VSS VSS gf180mcu_fd_sc_mcu7t5v0__nand4_1
XFILLER_97_675 VDD VDD VSS VSS gf180mcu_fd_sc_mcu7t5v0__fill_2
XFILLER_84_303 VDD VDD VSS VSS gf180mcu_fd_sc_mcu7t5v0__fillcap_8
X_2345_ _3654_/Q _4068_/Q _2357_/S _3654_/D VDD VDD VSS VSS gf180mcu_fd_sc_mcu7t5v0__mux2_2
XFILLER_111_485 VDD VDD VSS VSS gf180mcu_fd_sc_mcu7t5v0__fillcap_4
X_2276_ _4096_/Q _2281_/A1 VDD VDD VSS VSS gf180mcu_fd_sc_mcu7t5v0__clkinv_1
XFILLER_97_697 VDD VDD VSS VSS gf180mcu_fd_sc_mcu7t5v0__fill_2
XFILLER_38_731 VDD VDD VSS VSS gf180mcu_fd_sc_mcu7t5v0__fillcap_4
X_4015_ _4015_/D input92/Z _4045_/CLK _4015_/Q VDD VDD VSS VSS gf180mcu_fd_sc_mcu7t5v0__dffrnq_1
XFILLER_92_380 VDD VDD VSS VSS gf180mcu_fd_sc_mcu7t5v0__fillcap_4
XFILLER_16_49 VDD VDD VSS VSS gf180mcu_fd_sc_mcu7t5v0__fill_2
XFILLER_80_597 VDD VDD VSS VSS gf180mcu_fd_sc_mcu7t5v0__fillcap_64
XTAP_TAPCELL_ROW_51_946 VDD VSS gf180mcu_fd_sc_mcu7t5v0__filltie
XFILLER_52_299 VDD VDD VSS VSS gf180mcu_fd_sc_mcu7t5v0__fill_2
XFILLER_32_37 VDD VDD VSS VSS gf180mcu_fd_sc_mcu7t5v0__fillcap_64
XFILLER_119_530 VDD VDD VSS VSS gf180mcu_fd_sc_mcu7t5v0__fillcap_4
XFILLER_20_174 VDD VDD VSS VSS gf180mcu_fd_sc_mcu7t5v0__fill_1
XTAP_TAPCELL_ROW_31_692 VDD VSS gf180mcu_fd_sc_mcu7t5v0__filltie
XFILLER_0_546 VDD VDD VSS VSS gf180mcu_fd_sc_mcu7t5v0__fillcap_32
XFILLER_75_336 VDD VDD VSS VSS gf180mcu_fd_sc_mcu7t5v0__fillcap_4
XFILLER_29_731 VDD VDD VSS VSS gf180mcu_fd_sc_mcu7t5v0__fillcap_8
XFILLER_17_904 VDD VDD VSS VSS gf180mcu_fd_sc_mcu7t5v0__fillcap_4
XFILLER_90_317 VDD VDD VSS VSS gf180mcu_fd_sc_mcu7t5v0__fillcap_16
XFILLER_56_572 VDD VDD VSS VSS gf180mcu_fd_sc_mcu7t5v0__fillcap_16
XFILLER_71_520 VDD VDD VSS VSS gf180mcu_fd_sc_mcu7t5v0__fill_2
XTAP_TAPCELL_ROW_39_792 VDD VSS gf180mcu_fd_sc_mcu7t5v0__filltie
XFILLER_56_594 VDD VDD VSS VSS gf180mcu_fd_sc_mcu7t5v0__fill_1
XFILLER_43_277 VDD VDD VSS VSS gf180mcu_fd_sc_mcu7t5v0__fill_2
XFILLER_12_664 VDD VDD VSS VSS gf180mcu_fd_sc_mcu7t5v0__fill_1
XFILLER_12_642 VDD VDD VSS VSS gf180mcu_fd_sc_mcu7t5v0__fillcap_16
XFILLER_129_349 VDD VDD VSS VSS gf180mcu_fd_sc_mcu7t5v0__fill_1
XFILLER_129_338 VDD VDD VSS VSS gf180mcu_fd_sc_mcu7t5v0__fill_2
XFILLER_125_544 VDD VDD VSS VSS gf180mcu_fd_sc_mcu7t5v0__fill_2
XTAP_TAPCELL_ROW_59_1052 VDD VSS gf180mcu_fd_sc_mcu7t5v0__filltie
XFILLER_98_85 VDD VDD VSS VSS gf180mcu_fd_sc_mcu7t5v0__fillcap_16
XFILLER_121_772 VDD VDD VSS VSS gf180mcu_fd_sc_mcu7t5v0__fillcap_64
XFILLER_78_141 VDD VDD VSS VSS gf180mcu_fd_sc_mcu7t5v0__fillcap_32
XFILLER_120_271 VDD VDD VSS VSS gf180mcu_fd_sc_mcu7t5v0__fillcap_4
X_2130_ _3375_/A2 _2129_/Z _2142_/A1 VDD VDD VSS VSS gf180mcu_fd_sc_mcu7t5v0__nand2_1
XFILLER_120_293 VDD VDD VSS VSS gf180mcu_fd_sc_mcu7t5v0__fill_1
X_2061_ place52/Z _2061_/A2 _2062_/B VDD VDD VSS VSS gf180mcu_fd_sc_mcu7t5v0__nand2_1
XFILLER_94_667 VDD VDD VSS VSS gf180mcu_fd_sc_mcu7t5v0__fillcap_64
XFILLER_82_818 VDD VDD VSS VSS gf180mcu_fd_sc_mcu7t5v0__fill_1
XFILLER_82_807 VDD VDD VSS VSS gf180mcu_fd_sc_mcu7t5v0__fillcap_4
XFILLER_19_274 VDD VDD VSS VSS gf180mcu_fd_sc_mcu7t5v0__fillcap_4
XTAP_TAPCELL_ROW_83_1370 VDD VSS gf180mcu_fd_sc_mcu7t5v0__filltie
XFILLER_22_439 VDD VDD VSS VSS gf180mcu_fd_sc_mcu7t5v0__fill_1
XFILLER_50_737 VDD VDD VSS VSS gf180mcu_fd_sc_mcu7t5v0__fill_2
XFILLER_62_597 VDD VDD VSS VSS gf180mcu_fd_sc_mcu7t5v0__fillcap_16
X_1914_ _2887_/A1 _1910_/Z _1914_/B1 _1914_/B2 _1915_/C VDD VDD VSS VSS gf180mcu_fd_sc_mcu7t5v0__aoi22_1
X_2894_ _4031_/Q _2900_/S _2895_/B VDD VDD VSS VSS gf180mcu_fd_sc_mcu7t5v0__nand2_1
XPHY_EDGE_ROW_7_Left_140 VDD VSS gf180mcu_fd_sc_mcu7t5v0__endcap
X_1845_ _2013_/A4 _1935_/A4 _1901_/B VDD VDD VSS VSS gf180mcu_fd_sc_mcu7t5v0__nand2_1
XFILLER_128_382 VDD VDD VSS VSS gf180mcu_fd_sc_mcu7t5v0__fill_2
XFILLER_118_18 VDD VDD VSS VSS gf180mcu_fd_sc_mcu7t5v0__fill_2
XFILLER_131_514 VDD VDD VSS VSS gf180mcu_fd_sc_mcu7t5v0__fill_1
X_3446_ _4102_/Q _3418_/Z _3447_/A2 _3453_/I0 VDD VDD VSS VSS gf180mcu_fd_sc_mcu7t5v0__nand3_1
X_3377_ _4085_/Q _3407_/A2 _3394_/A4 _3378_/B VDD VDD VSS VSS gf180mcu_fd_sc_mcu7t5v0__nand3_1
XFILLER_97_450 VDD VDD VSS VSS gf180mcu_fd_sc_mcu7t5v0__fill_1
XFILLER_85_601 VDD VDD VSS VSS gf180mcu_fd_sc_mcu7t5v0__fillcap_16
XFILLER_111_282 VDD VDD VSS VSS gf180mcu_fd_sc_mcu7t5v0__fillcap_64
XFILLER_97_483 VDD VDD VSS VSS gf180mcu_fd_sc_mcu7t5v0__fillcap_4
XFILLER_57_314 VDD VDD VSS VSS gf180mcu_fd_sc_mcu7t5v0__fillcap_4
X_2328_ _4069_/Q _3647_/Q _2338_/S _3647_/D VDD VDD VSS VSS gf180mcu_fd_sc_mcu7t5v0__mux2_2
X_2259_ _2259_/I _2259_/ZN VDD VDD VSS VSS gf180mcu_fd_sc_mcu7t5v0__inv_1
XFILLER_84_177 VDD VDD VSS VSS gf180mcu_fd_sc_mcu7t5v0__fillcap_32
XFILLER_72_317 VDD VDD VSS VSS gf180mcu_fd_sc_mcu7t5v0__fillcap_4
XFILLER_72_328 VDD VDD VSS VSS gf180mcu_fd_sc_mcu7t5v0__fillcap_32
XFILLER_26_734 VDD VDD VSS VSS gf180mcu_fd_sc_mcu7t5v0__fill_1
XFILLER_14_907 VDD VDD VSS VSS gf180mcu_fd_sc_mcu7t5v0__fillcap_16
XTAP_TAPCELL_ROW_36_751 VDD VSS gf180mcu_fd_sc_mcu7t5v0__filltie
XFILLER_80_383 VDD VDD VSS VSS gf180mcu_fd_sc_mcu7t5v0__fill_2
XFILLER_40_247 VDD VDD VSS VSS gf180mcu_fd_sc_mcu7t5v0__fillcap_16
XFILLER_119_393 VDD VDD VSS VSS gf180mcu_fd_sc_mcu7t5v0__fill_2
XFILLER_107_544 VDD VDD VSS VSS gf180mcu_fd_sc_mcu7t5v0__fill_2
XFILLER_4_159 VDD VDD VSS VSS gf180mcu_fd_sc_mcu7t5v0__fill_1
XFILLER_103_772 VDD VDD VSS VSS gf180mcu_fd_sc_mcu7t5v0__fillcap_64
XFILLER_0_376 VDD VDD VSS VSS gf180mcu_fd_sc_mcu7t5v0__fillcap_32
XFILLER_64_807 VDD VDD VSS VSS gf180mcu_fd_sc_mcu7t5v0__fillcap_64
XFILLER_29_550 VDD VDD VSS VSS gf180mcu_fd_sc_mcu7t5v0__fillcap_8
XFILLER_17_734 VDD VDD VSS VSS gf180mcu_fd_sc_mcu7t5v0__fillcap_16
XFILLER_44_520 VDD VDD VSS VSS gf180mcu_fd_sc_mcu7t5v0__fillcap_4
XTAP_TAPCELL_ROW_106_1668 VDD VSS gf180mcu_fd_sc_mcu7t5v0__filltie
XFILLER_72_873 VDD VDD VSS VSS gf180mcu_fd_sc_mcu7t5v0__fill_2
XFILLER_16_244 VDD VDD VSS VSS gf180mcu_fd_sc_mcu7t5v0__fill_1
XFILLER_32_737 VDD VDD VSS VSS gf180mcu_fd_sc_mcu7t5v0__fillcap_64
XFILLER_44_597 VDD VDD VSS VSS gf180mcu_fd_sc_mcu7t5v0__fillcap_32
XTAP_TAPCELL_ROW_14_467 VDD VSS gf180mcu_fd_sc_mcu7t5v0__filltie
XFILLER_129_146 VDD VDD VSS VSS gf180mcu_fd_sc_mcu7t5v0__fill_2
XFILLER_69_6 VDD VDD VSS VSS gf180mcu_fd_sc_mcu7t5v0__fill_2
XFILLER_125_352 VDD VDD VSS VSS gf180mcu_fd_sc_mcu7t5v0__fillcap_16
XFILLER_125_385 VDD VDD VSS VSS gf180mcu_fd_sc_mcu7t5v0__fillcap_32
XFILLER_98_247 VDD VDD VSS VSS gf180mcu_fd_sc_mcu7t5v0__fillcap_16
XTAP_TAPCELL_ROW_130_1975 VDD VSS gf180mcu_fd_sc_mcu7t5v0__filltie
X_3231_ _4054_/Q _3984_/Q _4129_/D _4054_/D VDD VDD VSS VSS gf180mcu_fd_sc_mcu7t5v0__mux2_2
XFILLER_95_932 VDD VDD VSS VSS gf180mcu_fd_sc_mcu7t5v0__fill_2
X_3162_ _4021_/Q _3989_/Q _4129_/D _4021_/D VDD VDD VSS VSS gf180mcu_fd_sc_mcu7t5v0__mux2_2
X_2113_ _2185_/A1 _2152_/S _2167_/A2 VDD VDD VSS VSS gf180mcu_fd_sc_mcu7t5v0__nor2_1
XFILLER_12_2 VDD VDD VSS VSS gf180mcu_fd_sc_mcu7t5v0__fillcap_32
XFILLER_54_317 VDD VDD VSS VSS gf180mcu_fd_sc_mcu7t5v0__fillcap_16
XFILLER_66_177 VDD VDD VSS VSS gf180mcu_fd_sc_mcu7t5v0__fillcap_4
X_2044_ place71/Z place52/Z _2042_/Z _2045_/B VDD VDD VSS VSS gf180mcu_fd_sc_mcu7t5v0__nand3_1
XTAP_TAPCELL_ROW_33_710 VDD VSS gf180mcu_fd_sc_mcu7t5v0__filltie
XTAP_TAPCELL_ROW_33_721 VDD VSS gf180mcu_fd_sc_mcu7t5v0__filltie
X_3995_ _3995_/D input92/Z _4028_/CLK _3995_/Q VDD VDD VSS VSS gf180mcu_fd_sc_mcu7t5v0__dffrnq_1
XFILLER_22_247 VDD VDD VSS VSS gf180mcu_fd_sc_mcu7t5v0__fillcap_16
XFILLER_13_39 VDD VDD VSS VSS gf180mcu_fd_sc_mcu7t5v0__fillcap_16
X_2877_ _1863_/C _2900_/S _2877_/B _3886_/D VDD VDD VSS VSS gf180mcu_fd_sc_mcu7t5v0__oai21_1
X_1828_ _2899_/A1 _3898_/Q _1827_/Z _1833_/A2 VDD VDD VSS VSS gf180mcu_fd_sc_mcu7t5v0__nand3_1
XFILLER_117_842 VDD VDD VSS VSS gf180mcu_fd_sc_mcu7t5v0__fillcap_4
XPHY_EDGE_ROW_111_Right_111 VDD VSS gf180mcu_fd_sc_mcu7t5v0__endcap
X_3429_ _4104_/Q _3477_/A2 _3429_/A3 _3447_/A2 VDD VDD VSS VSS gf180mcu_fd_sc_mcu7t5v0__nand3_1
XFILLER_86_932 VDD VDD VSS VSS gf180mcu_fd_sc_mcu7t5v0__fill_2
XFILLER_100_731 VDD VDD VSS VSS gf180mcu_fd_sc_mcu7t5v0__fillcap_4
XFILLER_100_753 VDD VDD VSS VSS gf180mcu_fd_sc_mcu7t5v0__fillcap_4
XFILLER_46_807 VDD VDD VSS VSS gf180mcu_fd_sc_mcu7t5v0__fillcap_64
XFILLER_58_667 VDD VDD VSS VSS gf180mcu_fd_sc_mcu7t5v0__fillcap_32
XFILLER_85_486 VDD VDD VSS VSS gf180mcu_fd_sc_mcu7t5v0__fillcap_4
XFILLER_14_737 VDD VDD VSS VSS gf180mcu_fd_sc_mcu7t5v0__fillcap_32
XFILLER_26_597 VDD VDD VSS VSS gf180mcu_fd_sc_mcu7t5v0__fillcap_8
XFILLER_110_85 VDD VDD VSS VSS gf180mcu_fd_sc_mcu7t5v0__fillcap_16
XTAP_TAPCELL_ROW_101_1598 VDD VSS gf180mcu_fd_sc_mcu7t5v0__filltie
XTAP_TAPCELL_ROW_11_426 VDD VSS gf180mcu_fd_sc_mcu7t5v0__filltie
XFILLER_70_45 VDD VDD VSS VSS gf180mcu_fd_sc_mcu7t5v0__fillcap_4
XFILLER_6_925 VDD VDD VSS VSS gf180mcu_fd_sc_mcu7t5v0__fillcap_8
XFILLER_119_72 VDD VDD VSS VSS gf180mcu_fd_sc_mcu7t5v0__fillcap_64
XFILLER_108_831 VDD VDD VSS VSS gf180mcu_fd_sc_mcu7t5v0__fillcap_4
XFILLER_107_352 VDD VDD VSS VSS gf180mcu_fd_sc_mcu7t5v0__fillcap_32
XTAP_TAPCELL_ROW_56_1011 VDD VSS gf180mcu_fd_sc_mcu7t5v0__filltie
XPHY_EDGE_ROW_79_Left_212 VDD VSS gf180mcu_fd_sc_mcu7t5v0__endcap
XFILLER_123_889 VDD VDD VSS VSS gf180mcu_fd_sc_mcu7t5v0__fillcap_4
XFILLER_122_377 VDD VDD VSS VSS gf180mcu_fd_sc_mcu7t5v0__fillcap_8
XFILLER_77_932 VDD VDD VSS VSS gf180mcu_fd_sc_mcu7t5v0__fill_2
XFILLER_1_696 VDD VDD VSS VSS gf180mcu_fd_sc_mcu7t5v0__fillcap_4
XFILLER_76_453 VDD VDD VSS VSS gf180mcu_fd_sc_mcu7t5v0__fill_2
XFILLER_48_122 VDD VDD VSS VSS gf180mcu_fd_sc_mcu7t5v0__fillcap_32
XFILLER_92_924 VDD VDD VSS VSS gf180mcu_fd_sc_mcu7t5v0__fillcap_8
XFILLER_91_412 VDD VDD VSS VSS gf180mcu_fd_sc_mcu7t5v0__fillcap_8
XFILLER_36_317 VDD VDD VSS VSS gf180mcu_fd_sc_mcu7t5v0__fillcap_16
XFILLER_48_177 VDD VDD VSS VSS gf180mcu_fd_sc_mcu7t5v0__fillcap_64
XTAP_TAPCELL_ROW_19_537 VDD VSS gf180mcu_fd_sc_mcu7t5v0__filltie
XFILLER_29_391 VDD VDD VSS VSS gf180mcu_fd_sc_mcu7t5v0__fillcap_4
XFILLER_63_136 VDD VDD VSS VSS gf180mcu_fd_sc_mcu7t5v0__fillcap_4
XFILLER_91_456 VDD VDD VSS VSS gf180mcu_fd_sc_mcu7t5v0__fillcap_4
XTAP_TAPCELL_ROW_67_1151 VDD VSS gf180mcu_fd_sc_mcu7t5v0__filltie
XPHY_EDGE_ROW_88_Left_221 VDD VSS gf180mcu_fd_sc_mcu7t5v0__endcap
XTAP_TAPCELL_ROW_67_1162 VDD VSS gf180mcu_fd_sc_mcu7t5v0__filltie
X_3780_ _3780_/D _4023_/CLK _3780_/Q VDD VDD VSS VSS gf180mcu_fd_sc_mcu7t5v0__dffq_1
XTAP_TAPCELL_ROW_119_1837 VDD VSS gf180mcu_fd_sc_mcu7t5v0__filltie
X_2662_ place90/Z _3789_/Q _2676_/S _3789_/D VDD VDD VSS VSS gf180mcu_fd_sc_mcu7t5v0__mux2_2
XFILLER_114_801 VDD VDD VSS VSS gf180mcu_fd_sc_mcu7t5v0__fillcap_4
XPHY_EDGE_ROW_97_Left_230 VDD VSS gf180mcu_fd_sc_mcu7t5v0__endcap
XFILLER_99_556 VDD VDD VSS VSS gf180mcu_fd_sc_mcu7t5v0__fillcap_4
XFILLER_68_932 VDD VDD VSS VSS gf180mcu_fd_sc_mcu7t5v0__fill_2
XFILLER_28_807 VDD VDD VSS VSS gf180mcu_fd_sc_mcu7t5v0__fillcap_4
XFILLER_27_306 VDD VDD VSS VSS gf180mcu_fd_sc_mcu7t5v0__fill_2
XFILLER_67_453 VDD VDD VSS VSS gf180mcu_fd_sc_mcu7t5v0__fill_1
XFILLER_131_18 VDD VDD VSS VSS gf180mcu_fd_sc_mcu7t5v0__fillcap_16
XFILLER_55_648 VDD VDD VSS VSS gf180mcu_fd_sc_mcu7t5v0__fill_2
X_2027_ place52/Z _2027_/A2 _2028_/B VDD VDD VSS VSS gf180mcu_fd_sc_mcu7t5v0__nand2_1
XFILLER_36_873 VDD VDD VSS VSS gf180mcu_fd_sc_mcu7t5v0__fill_2
XFILLER_23_556 VDD VDD VSS VSS gf180mcu_fd_sc_mcu7t5v0__fillcap_4
XFILLER_35_394 VDD VDD VSS VSS gf180mcu_fd_sc_mcu7t5v0__fill_1
XTAP_TAPCELL_ROW_46_890 VDD VSS gf180mcu_fd_sc_mcu7t5v0__filltie
X_3978_ _3978_/D _2279_/I _3978_/CLK _3978_/Q VDD VDD VSS VSS gf180mcu_fd_sc_mcu7t5v0__dffrnq_1
XFILLER_11_718 VDD VDD VSS VSS gf180mcu_fd_sc_mcu7t5v0__fill_1
X_2929_ _4031_/Q _3911_/Q _2972_/S _3911_/D VDD VDD VSS VSS gf180mcu_fd_sc_mcu7t5v0__mux2_2
XFILLER_108_138 VDD VDD VSS VSS gf180mcu_fd_sc_mcu7t5v0__fillcap_8
XTAP_TAPCELL_ROW_94_1509 VDD VSS gf180mcu_fd_sc_mcu7t5v0__filltie
XFILLER_40_37 VDD VDD VSS VSS gf180mcu_fd_sc_mcu7t5v0__fillcap_32
XFILLER_117_672 VDD VDD VSS VSS gf180mcu_fd_sc_mcu7t5v0__fill_1
XFILLER_3_906 VDD VDD VSS VSS gf180mcu_fd_sc_mcu7t5v0__fillcap_4
XFILLER_3_928 VDD VDD VSS VSS gf180mcu_fd_sc_mcu7t5v0__fillcap_4
XFILLER_120_804 VDD VDD VSS VSS gf180mcu_fd_sc_mcu7t5v0__fill_1
XFILLER_104_333 VDD VDD VSS VSS gf180mcu_fd_sc_mcu7t5v0__fill_1
XFILLER_104_355 VDD VDD VSS VSS gf180mcu_fd_sc_mcu7t5v0__fillcap_8
XFILLER_59_932 VDD VDD VSS VSS gf180mcu_fd_sc_mcu7t5v0__fill_2
XFILLER_18_317 VDD VDD VSS VSS gf180mcu_fd_sc_mcu7t5v0__fillcap_16
XFILLER_100_594 VDD VDD VSS VSS gf180mcu_fd_sc_mcu7t5v0__fill_1
XFILLER_45_136 VDD VDD VSS VSS gf180mcu_fd_sc_mcu7t5v0__fillcap_4
XFILLER_46_637 VDD VDD VSS VSS gf180mcu_fd_sc_mcu7t5v0__fillcap_4
XTAP_TAPCELL_ROW_103_1627 VDD VSS gf180mcu_fd_sc_mcu7t5v0__filltie
XTAP_TAPCELL_ROW_24_595 VDD VSS gf180mcu_fd_sc_mcu7t5v0__filltie
XTAP_TAPCELL_ROW_62_1092 VDD VSS gf180mcu_fd_sc_mcu7t5v0__filltie
XFILLER_5_276 VDD VDD VSS VSS gf180mcu_fd_sc_mcu7t5v0__fillcap_4
XFILLER_123_664 VDD VDD VSS VSS gf180mcu_fd_sc_mcu7t5v0__fillcap_32
XTAP_TAPCELL_ROW_114_1767 VDD VSS gf180mcu_fd_sc_mcu7t5v0__filltie
XFILLER_96_559 VDD VDD VSS VSS gf180mcu_fd_sc_mcu7t5v0__fillcap_16
XFILLER_49_486 VDD VDD VSS VSS gf180mcu_fd_sc_mcu7t5v0__fillcap_4
XFILLER_18_873 VDD VDD VSS VSS gf180mcu_fd_sc_mcu7t5v0__fill_2
XFILLER_52_629 VDD VDD VSS VSS gf180mcu_fd_sc_mcu7t5v0__fillcap_4
XFILLER_64_489 VDD VDD VSS VSS gf180mcu_fd_sc_mcu7t5v0__fillcap_16
X_3901_ _3901_/D _4157_/RN _4148_/CLK _3901_/Q VDD VDD VSS VSS gf180mcu_fd_sc_mcu7t5v0__dffsnq_1
X_3832_ _3832_/D _3835_/CLK _3832_/Q VDD VDD VSS VSS gf180mcu_fd_sc_mcu7t5v0__dffq_1
XFILLER_33_887 VDD VDD VSS VSS gf180mcu_fd_sc_mcu7t5v0__fillcap_16
XFILLER_60_662 VDD VDD VSS VSS gf180mcu_fd_sc_mcu7t5v0__fill_2
XFILLER_118_403 VDD VDD VSS VSS gf180mcu_fd_sc_mcu7t5v0__fillcap_8
X_3763_ _3763_/D _4159_/CLK _3763_/Q VDD VDD VSS VSS gf180mcu_fd_sc_mcu7t5v0__dffq_1
X_2714_ _3813_/Q place90/Z _2728_/S _3813_/D VDD VDD VSS VSS gf180mcu_fd_sc_mcu7t5v0__mux2_2
X_3694_ _3694_/D _4072_/CLK _3694_/Q VDD VDD VSS VSS gf180mcu_fd_sc_mcu7t5v0__dffq_1
XFILLER_126_18 VDD VDD VSS VSS gf180mcu_fd_sc_mcu7t5v0__fill_1
X_2576_ _4114_/Q _2576_/A2 _3522_/A1 VDD VDD VSS VSS gf180mcu_fd_sc_mcu7t5v0__nand2_1
XFILLER_101_314 VDD VDD VSS VSS gf180mcu_fd_sc_mcu7t5v0__fill_2
XFILLER_59_228 VDD VDD VSS VSS gf180mcu_fd_sc_mcu7t5v0__fill_2
XFILLER_110_881 VDD VDD VSS VSS gf180mcu_fd_sc_mcu7t5v0__fill_1
XFILLER_28_648 VDD VDD VSS VSS gf180mcu_fd_sc_mcu7t5v0__fillcap_16
XFILLER_51_640 VDD VDD VSS VSS gf180mcu_fd_sc_mcu7t5v0__fillcap_4
XFILLER_24_898 VDD VDD VSS VSS gf180mcu_fd_sc_mcu7t5v0__fill_1
XTAP_TAPCELL_ROW_41_819 VDD VSS gf180mcu_fd_sc_mcu7t5v0__filltie
XFILLER_51_14 VDD VDD VSS VSS gf180mcu_fd_sc_mcu7t5v0__fill_2
XTAP_TAPCELL_ROW_21_554 VDD VSS gf180mcu_fd_sc_mcu7t5v0__filltie
XFILLER_51_58 VDD VDD VSS VSS gf180mcu_fd_sc_mcu7t5v0__fillcap_8
XTAP_TAPCELL_ROW_21_565 VDD VSS gf180mcu_fd_sc_mcu7t5v0__filltie
XFILLER_125_907 VDD VDD VSS VSS gf180mcu_fd_sc_mcu7t5v0__fill_2
XFILLER_3_736 VDD VDD VSS VSS gf180mcu_fd_sc_mcu7t5v0__fill_2
XFILLER_104_174 VDD VDD VSS VSS gf180mcu_fd_sc_mcu7t5v0__fill_1
XFILLER_59_740 VDD VDD VSS VSS gf180mcu_fd_sc_mcu7t5v0__fillcap_8
XFILLER_120_667 VDD VDD VSS VSS gf180mcu_fd_sc_mcu7t5v0__fillcap_16
XFILLER_76_66 VDD VDD VSS VSS gf180mcu_fd_sc_mcu7t5v0__fillcap_32
XFILLER_19_615 VDD VDD VSS VSS gf180mcu_fd_sc_mcu7t5v0__fillcap_8
XTAP_TAPCELL_ROW_49_919 VDD VSS gf180mcu_fd_sc_mcu7t5v0__filltie
XFILLER_59_784 VDD VDD VSS VSS gf180mcu_fd_sc_mcu7t5v0__fill_1
XFILLER_65_209 VDD VDD VSS VSS gf180mcu_fd_sc_mcu7t5v0__fill_1
Xplace65 _2974_/Z _3041_/S VDD VDD VSS VSS gf180mcu_fd_sc_mcu7t5v0__buf_8
Xplace54 place54/I _2900_/S VDD VDD VSS VSS gf180mcu_fd_sc_mcu7t5v0__buf_8
XFILLER_18_136 VDD VDD VSS VSS gf180mcu_fd_sc_mcu7t5v0__fillcap_32
XTAP_TAPCELL_ROW_29_665 VDD VSS gf180mcu_fd_sc_mcu7t5v0__filltie
Xplace76 _4116_/Q place76/Z VDD VDD VSS VSS gf180mcu_fd_sc_mcu7t5v0__buf_8
Xplace87 _4024_/Q place87/Z VDD VDD VSS VSS gf180mcu_fd_sc_mcu7t5v0__buf_8
XFILLER_42_640 VDD VDD VSS VSS gf180mcu_fd_sc_mcu7t5v0__fillcap_16
XTAP_TAPCELL_ROW_64_1121 VDD VSS gf180mcu_fd_sc_mcu7t5v0__filltie
XFILLER_42_684 VDD VDD VSS VSS gf180mcu_fd_sc_mcu7t5v0__fillcap_32
XFILLER_128_734 VDD VDD VSS VSS gf180mcu_fd_sc_mcu7t5v0__fill_1
XFILLER_41_80 VDD VDD VSS VSS gf180mcu_fd_sc_mcu7t5v0__fillcap_4
X_2430_ _3692_/Q _4074_/Q _2430_/S _3692_/D VDD VDD VSS VSS gf180mcu_fd_sc_mcu7t5v0__mux2_2
XTAP_TAPCELL_ROW_75_1261 VDD VSS gf180mcu_fd_sc_mcu7t5v0__filltie
X_2361_ _2379_/A2 _2360_/Z place51/I VDD VDD VSS VSS gf180mcu_fd_sc_mcu7t5v0__nor2_1
XFILLER_111_656 VDD VDD VSS VSS gf180mcu_fd_sc_mcu7t5v0__fillcap_4
X_4100_ _4100_/D _2279_/I _4112_/CLK _4100_/Q VDD VDD VSS VSS gf180mcu_fd_sc_mcu7t5v0__dffrnq_1
X_2292_ _3633_/Q _4071_/Q _2298_/S _3633_/D VDD VDD VSS VSS gf180mcu_fd_sc_mcu7t5v0__mux2_2
XFILLER_69_559 VDD VDD VSS VSS gf180mcu_fd_sc_mcu7t5v0__fill_1
XFILLER_96_378 VDD VDD VSS VSS gf180mcu_fd_sc_mcu7t5v0__fillcap_4
X_4031_ _4031_/D _4148_/RN _4036_/CLK _4031_/Q VDD VDD VSS VSS gf180mcu_fd_sc_mcu7t5v0__dffrnq_1
XPHY_EDGE_ROW_16_Left_149 VDD VSS gf180mcu_fd_sc_mcu7t5v0__endcap
XFILLER_1_290 VDD VDD VSS VSS gf180mcu_fd_sc_mcu7t5v0__fillcap_4
XTAP_TAPCELL_ROW_127_1936 VDD VSS gf180mcu_fd_sc_mcu7t5v0__filltie
XFILLER_110_177 VDD VDD VSS VSS gf180mcu_fd_sc_mcu7t5v0__fillcap_32
XFILLER_77_570 VDD VDD VSS VSS gf180mcu_fd_sc_mcu7t5v0__fill_2
XFILLER_92_540 VDD VDD VSS VSS gf180mcu_fd_sc_mcu7t5v0__fillcap_8
XFILLER_92_584 VDD VDD VSS VSS gf180mcu_fd_sc_mcu7t5v0__fillcap_8
XFILLER_53_927 VDD VDD VSS VSS gf180mcu_fd_sc_mcu7t5v0__fillcap_4
X_3815_ _3815_/D _4159_/CLK _3815_/Q VDD VDD VSS VSS gf180mcu_fd_sc_mcu7t5v0__dffq_1
XPHY_EDGE_ROW_25_Left_158 VDD VSS gf180mcu_fd_sc_mcu7t5v0__endcap
XFILLER_118_211 VDD VDD VSS VSS gf180mcu_fd_sc_mcu7t5v0__fillcap_4
X_3746_ _3746_/D _4094_/CLK _3746_/Q VDD VDD VSS VSS gf180mcu_fd_sc_mcu7t5v0__dffq_1
XFILLER_118_266 VDD VDD VSS VSS gf180mcu_fd_sc_mcu7t5v0__fillcap_4
X_3677_ _3677_/D _3749_/CLK _3677_/Q VDD VDD VSS VSS gf180mcu_fd_sc_mcu7t5v0__dffq_1
XFILLER_88_802 VDD VDD VSS VSS gf180mcu_fd_sc_mcu7t5v0__fill_2
X_2628_ place88/Z _3775_/Q _2638_/S _3775_/D VDD VDD VSS VSS gf180mcu_fd_sc_mcu7t5v0__mux2_2
Xoutput164 _2263_/ZN s_axi_rdata[25] VDD VDD VSS VSS gf180mcu_fd_sc_mcu7t5v0__dlyb_1
Xoutput153 _2243_/ZN s_axi_rdata[15] VDD VDD VSS VSS gf180mcu_fd_sc_mcu7t5v0__dlyb_1
Xoutput175 _2208_/ZN s_axi_rdata[6] VDD VDD VSS VSS gf180mcu_fd_sc_mcu7t5v0__dlyb_1
XFILLER_99_150 VDD VDD VSS VSS gf180mcu_fd_sc_mcu7t5v0__fillcap_4
XFILLER_87_345 VDD VDD VSS VSS gf180mcu_fd_sc_mcu7t5v0__fillcap_4
XPHY_EDGE_ROW_34_Left_167 VDD VSS gf180mcu_fd_sc_mcu7t5v0__endcap
XFILLER_102_667 VDD VDD VSS VSS gf180mcu_fd_sc_mcu7t5v0__fillcap_16
XFILLER_56_754 VDD VDD VSS VSS gf180mcu_fd_sc_mcu7t5v0__fillcap_32
XFILLER_83_562 VDD VDD VSS VSS gf180mcu_fd_sc_mcu7t5v0__fillcap_8
XFILLER_71_702 VDD VDD VSS VSS gf180mcu_fd_sc_mcu7t5v0__fillcap_8
XFILLER_71_746 VDD VDD VSS VSS gf180mcu_fd_sc_mcu7t5v0__fillcap_16
XFILLER_15_139 VDD VDD VSS VSS gf180mcu_fd_sc_mcu7t5v0__fill_1
XTAP_TAPCELL_ROW_26_624 VDD VSS gf180mcu_fd_sc_mcu7t5v0__filltie
XFILLER_70_223 VDD VDD VSS VSS gf180mcu_fd_sc_mcu7t5v0__fillcap_16
XFILLER_24_662 VDD VDD VSS VSS gf180mcu_fd_sc_mcu7t5v0__fill_2
XTAP_TAPCELL_ROW_54_988 VDD VSS gf180mcu_fd_sc_mcu7t5v0__filltie
XPHY_EDGE_ROW_43_Left_176 VDD VSS gf180mcu_fd_sc_mcu7t5v0__endcap
XFILLER_51_492 VDD VDD VSS VSS gf180mcu_fd_sc_mcu7t5v0__fillcap_8
XFILLER_62_79 VDD VDD VSS VSS gf180mcu_fd_sc_mcu7t5v0__fillcap_16
XFILLER_11_72 VDD VDD VSS VSS gf180mcu_fd_sc_mcu7t5v0__fillcap_32
XFILLER_127_72 VDD VDD VSS VSS gf180mcu_fd_sc_mcu7t5v0__fill_1
XTAP_TAPCELL_ROW_111_1726 VDD VSS gf180mcu_fd_sc_mcu7t5v0__filltie
XFILLER_87_43 VDD VDD VSS VSS gf180mcu_fd_sc_mcu7t5v0__fill_2
XPHY_EDGE_ROW_52_Left_185 VDD VSS gf180mcu_fd_sc_mcu7t5v0__endcap
XFILLER_121_932 VDD VDD VSS VSS gf180mcu_fd_sc_mcu7t5v0__fill_2
XFILLER_78_312 VDD VDD VSS VSS gf180mcu_fd_sc_mcu7t5v0__fill_2
XTAP_TAPCELL_ROW_6_360 VDD VSS gf180mcu_fd_sc_mcu7t5v0__filltie
XFILLER_87_890 VDD VDD VSS VSS gf180mcu_fd_sc_mcu7t5v0__fill_2
XFILLER_59_570 VDD VDD VSS VSS gf180mcu_fd_sc_mcu7t5v0__fillcap_4
XTAP_TAPCELL_ROW_70_1191 VDD VSS gf180mcu_fd_sc_mcu7t5v0__filltie
XFILLER_74_584 VDD VDD VSS VSS gf180mcu_fd_sc_mcu7t5v0__fillcap_8
XFILLER_35_927 VDD VDD VSS VSS gf180mcu_fd_sc_mcu7t5v0__fillcap_4
XTAP_TAPCELL_ROW_109_1699 VDD VSS gf180mcu_fd_sc_mcu7t5v0__filltie
XFILLER_61_212 VDD VDD VSS VSS gf180mcu_fd_sc_mcu7t5v0__fillcap_8
XTAP_TAPCELL_ROW_122_1866 VDD VSS gf180mcu_fd_sc_mcu7t5v0__filltie
XPHY_EDGE_ROW_61_Left_194 VDD VSS gf180mcu_fd_sc_mcu7t5v0__endcap
XTAP_TAPCELL_ROW_122_1877 VDD VSS gf180mcu_fd_sc_mcu7t5v0__filltie
X_1930_ _1920_/Z _1924_/Z _1927_/Z _1930_/B _1931_/A3 VDD VDD VSS VSS gf180mcu_fd_sc_mcu7t5v0__oai31_1
X_1861_ _3885_/Q _2875_/A1 VDD VDD VSS VSS gf180mcu_fd_sc_mcu7t5v0__clkinv_1
XFILLER_128_520 VDD VDD VSS VSS gf180mcu_fd_sc_mcu7t5v0__fillcap_4
X_3600_ _3599_/Z _4156_/Q _3600_/S _4156_/D VDD VDD VSS VSS gf180mcu_fd_sc_mcu7t5v0__mux2_2
X_3531_ place75/Z place76/Z place74/Z _3500_/I _3532_/A2 VDD VDD VSS VSS gf180mcu_fd_sc_mcu7t5v0__nand4_1
XFILLER_116_737 VDD VDD VSS VSS gf180mcu_fd_sc_mcu7t5v0__fillcap_32
Xinput99 s_axi_arvalid _1968_/I VDD VDD VSS VSS gf180mcu_fd_sc_mcu7t5v0__dlyb_1
X_3462_ _4104_/Q _3462_/A2 _3462_/B _3468_/A2 VDD VDD VSS VSS gf180mcu_fd_sc_mcu7t5v0__oai21_1
XFILLER_124_781 VDD VDD VSS VSS gf180mcu_fd_sc_mcu7t5v0__fill_2
X_3393_ _4090_/Q _3395_/A1 VDD VDD VSS VSS gf180mcu_fd_sc_mcu7t5v0__clkinv_1
XFILLER_42_2 VDD VDD VSS VSS gf180mcu_fd_sc_mcu7t5v0__fillcap_32
XFILLER_69_301 VDD VDD VSS VSS gf180mcu_fd_sc_mcu7t5v0__fill_2
XFILLER_29_209 VDD VDD VSS VSS gf180mcu_fd_sc_mcu7t5v0__fill_1
X_2275_ _2275_/I _2275_/ZN VDD VDD VSS VSS gf180mcu_fd_sc_mcu7t5v0__inv_1
X_4014_ _4014_/D input92/Z _4045_/CLK _4014_/Q VDD VDD VSS VSS gf180mcu_fd_sc_mcu7t5v0__dffrnq_1
XTAP_TAPCELL_ROW_88_1430 VDD VSS gf180mcu_fd_sc_mcu7t5v0__filltie
XFILLER_65_540 VDD VDD VSS VSS gf180mcu_fd_sc_mcu7t5v0__fillcap_8
XFILLER_37_275 VDD VDD VSS VSS gf180mcu_fd_sc_mcu7t5v0__fillcap_4
XFILLER_65_562 VDD VDD VSS VSS gf180mcu_fd_sc_mcu7t5v0__fillcap_64
XFILLER_53_757 VDD VDD VSS VSS gf180mcu_fd_sc_mcu7t5v0__fillcap_8
XTAP_TAPCELL_ROW_51_947 VDD VSS gf180mcu_fd_sc_mcu7t5v0__filltie
XFILLER_21_632 VDD VDD VSS VSS gf180mcu_fd_sc_mcu7t5v0__fillcap_4
XFILLER_33_492 VDD VDD VSS VSS gf180mcu_fd_sc_mcu7t5v0__fillcap_64
XTAP_TAPCELL_ROW_99_1570 VDD VSS gf180mcu_fd_sc_mcu7t5v0__filltie
XTAP_TAPCELL_ROW_31_693 VDD VSS gf180mcu_fd_sc_mcu7t5v0__filltie
X_3729_ _3729_/D _3729_/CLK _3729_/Q VDD VDD VSS VSS gf180mcu_fd_sc_mcu7t5v0__dffq_1
XFILLER_106_247 VDD VDD VSS VSS gf180mcu_fd_sc_mcu7t5v0__fillcap_16
XFILLER_121_206 VDD VDD VSS VSS gf180mcu_fd_sc_mcu7t5v0__fillcap_4
XFILLER_0_503 VDD VDD VSS VSS gf180mcu_fd_sc_mcu7t5v0__fillcap_4
XFILLER_103_932 VDD VDD VSS VSS gf180mcu_fd_sc_mcu7t5v0__fill_2
XFILLER_102_453 VDD VDD VSS VSS gf180mcu_fd_sc_mcu7t5v0__fill_2
XFILLER_87_142 VDD VDD VSS VSS gf180mcu_fd_sc_mcu7t5v0__fillcap_8
XFILLER_130_784 VDD VDD VSS VSS gf180mcu_fd_sc_mcu7t5v0__fill_2
XTAP_TAPCELL_ROW_3_330 VDD VSS gf180mcu_fd_sc_mcu7t5v0__filltie
XFILLER_90_307 VDD VDD VSS VSS gf180mcu_fd_sc_mcu7t5v0__fillcap_8
XFILLER_17_927 VDD VDD VSS VSS gf180mcu_fd_sc_mcu7t5v0__fillcap_4
XFILLER_29_776 VDD VDD VSS VSS gf180mcu_fd_sc_mcu7t5v0__fill_1
XTAP_TAPCELL_ROW_39_793 VDD VSS gf180mcu_fd_sc_mcu7t5v0__filltie
XFILLER_43_212 VDD VDD VSS VSS gf180mcu_fd_sc_mcu7t5v0__fillcap_8
XFILLER_32_919 VDD VDD VSS VSS gf180mcu_fd_sc_mcu7t5v0__fillcap_8
XFILLER_43_245 VDD VDD VSS VSS gf180mcu_fd_sc_mcu7t5v0__fillcap_32
XPHY_EDGE_ROW_125_Right_125 VDD VSS gf180mcu_fd_sc_mcu7t5v0__endcap
XFILLER_11_120 VDD VDD VSS VSS gf180mcu_fd_sc_mcu7t5v0__fillcap_16
XFILLER_11_142 VDD VDD VSS VSS gf180mcu_fd_sc_mcu7t5v0__fillcap_4
XFILLER_98_53 VDD VDD VSS VSS gf180mcu_fd_sc_mcu7t5v0__fillcap_32
XTAP_TAPCELL_ROW_59_1053 VDD VSS gf180mcu_fd_sc_mcu7t5v0__filltie
XFILLER_113_718 VDD VDD VSS VSS gf180mcu_fd_sc_mcu7t5v0__fillcap_8
XFILLER_3_352 VDD VDD VSS VSS gf180mcu_fd_sc_mcu7t5v0__fillcap_4
XFILLER_79_632 VDD VDD VSS VSS gf180mcu_fd_sc_mcu7t5v0__fillcap_64
XTAP_TAPCELL_ROW_72_1220 VDD VSS gf180mcu_fd_sc_mcu7t5v0__filltie
XFILLER_67_838 VDD VDD VSS VSS gf180mcu_fd_sc_mcu7t5v0__fill_2
X_2060_ _2097_/A2 _2097_/A3 _2061_/A2 _2062_/A2 VDD VDD VSS VSS gf180mcu_fd_sc_mcu7t5v0__nand3_2
XFILLER_35_702 VDD VDD VSS VSS gf180mcu_fd_sc_mcu7t5v0__fillcap_16
XFILLER_47_562 VDD VDD VSS VSS gf180mcu_fd_sc_mcu7t5v0__fillcap_4
XFILLER_74_381 VDD VDD VSS VSS gf180mcu_fd_sc_mcu7t5v0__fillcap_4
XFILLER_90_874 VDD VDD VSS VSS gf180mcu_fd_sc_mcu7t5v0__fill_1
X_2962_ _4047_/Q _3927_/Q _2972_/S _3927_/D VDD VDD VSS VSS gf180mcu_fd_sc_mcu7t5v0__mux2_2
XTAP_TAPCELL_ROW_83_1371 VDD VSS gf180mcu_fd_sc_mcu7t5v0__filltie
XTAP_TAPCELL_ROW_83_1360 VDD VSS gf180mcu_fd_sc_mcu7t5v0__filltie
XFILLER_15_481 VDD VDD VSS VSS gf180mcu_fd_sc_mcu7t5v0__fillcap_8
XFILLER_34_278 VDD VDD VSS VSS gf180mcu_fd_sc_mcu7t5v0__fill_2
X_1913_ _1913_/A1 _1935_/A4 _1910_/S _1913_/B2 _1914_/B2 VDD VDD VSS VSS gf180mcu_fd_sc_mcu7t5v0__aoi22_1
X_1844_ _4141_/Q _1901_/C VDD VDD VSS VSS gf180mcu_fd_sc_mcu7t5v0__inv_1
XFILLER_116_523 VDD VDD VSS VSS gf180mcu_fd_sc_mcu7t5v0__fill_2
X_3514_ _4113_/Q _3514_/A2 _4113_/D VDD VDD VSS VSS gf180mcu_fd_sc_mcu7t5v0__xor2_2
XFILLER_104_707 VDD VDD VSS VSS gf180mcu_fd_sc_mcu7t5v0__fillcap_4
X_3445_ _4101_/Q _3445_/A2 _3445_/B _4101_/D VDD VDD VSS VSS gf180mcu_fd_sc_mcu7t5v0__oai21_2
XFILLER_131_559 VDD VDD VSS VSS gf180mcu_fd_sc_mcu7t5v0__fill_1
XFILLER_112_751 VDD VDD VSS VSS gf180mcu_fd_sc_mcu7t5v0__fillcap_16
X_3376_ _3407_/A2 _3394_/A4 _3376_/Z VDD VDD VSS VSS gf180mcu_fd_sc_mcu7t5v0__or2_1
XFILLER_69_142 VDD VDD VSS VSS gf180mcu_fd_sc_mcu7t5v0__fill_2
XFILLER_58_827 VDD VDD VSS VSS gf180mcu_fd_sc_mcu7t5v0__fill_1
X_2258_ _3956_/Q place63/Z place67/Z _3981_/Q _3924_/Q place72/Z _2259_/I VDD VDD
+ VSS VSS gf180mcu_fd_sc_mcu7t5v0__aoi222_1
XPHY_EDGE_ROW_108_Left_241 VDD VSS gf180mcu_fd_sc_mcu7t5v0__endcap
XFILLER_85_679 VDD VDD VSS VSS gf180mcu_fd_sc_mcu7t5v0__fillcap_16
XFILLER_66_871 VDD VDD VSS VSS gf180mcu_fd_sc_mcu7t5v0__fillcap_4
X_2189_ _3714_/Q _3722_/Q _3730_/Q _3738_/Q place79/Z place78/Z _2189_/Z VDD VDD VSS
+ VSS gf180mcu_fd_sc_mcu7t5v0__mux4_1
XFILLER_25_212 VDD VDD VSS VSS gf180mcu_fd_sc_mcu7t5v0__fillcap_64
XTAP_TAPCELL_ROW_36_752 VDD VSS gf180mcu_fd_sc_mcu7t5v0__filltie
XFILLER_22_930 VDD VDD VSS VSS gf180mcu_fd_sc_mcu7t5v0__fillcap_4
XPHY_EDGE_ROW_117_Left_250 VDD VSS gf180mcu_fd_sc_mcu7t5v0__endcap
XFILLER_107_578 VDD VDD VSS VSS gf180mcu_fd_sc_mcu7t5v0__fillcap_8
XFILLER_122_548 VDD VDD VSS VSS gf180mcu_fd_sc_mcu7t5v0__fill_2
XFILLER_76_613 VDD VDD VSS VSS gf180mcu_fd_sc_mcu7t5v0__fillcap_8
XFILLER_124_73 VDD VDD VSS VSS gf180mcu_fd_sc_mcu7t5v0__fill_1
XFILLER_91_627 VDD VDD VSS VSS gf180mcu_fd_sc_mcu7t5v0__fill_2
XFILLER_17_702 VDD VDD VSS VSS gf180mcu_fd_sc_mcu7t5v0__fillcap_32
XFILLER_29_562 VDD VDD VSS VSS gf180mcu_fd_sc_mcu7t5v0__fillcap_8
XFILLER_84_77 VDD VDD VSS VSS gf180mcu_fd_sc_mcu7t5v0__fillcap_4
XFILLER_56_392 VDD VDD VSS VSS gf180mcu_fd_sc_mcu7t5v0__fillcap_32
XTAP_TAPCELL_ROW_106_1669 VDD VSS gf180mcu_fd_sc_mcu7t5v0__filltie
XTAP_TAPCELL_ROW_106_1658 VDD VSS gf180mcu_fd_sc_mcu7t5v0__filltie
XFILLER_9_912 VDD VDD VSS VSS gf180mcu_fd_sc_mcu7t5v0__fillcap_16
XTAP_TAPCELL_ROW_14_468 VDD VSS gf180mcu_fd_sc_mcu7t5v0__filltie
XFILLER_33_92 VDD VDD VSS VSS gf180mcu_fd_sc_mcu7t5v0__fill_2
XTAP_TAPCELL_ROW_130_1976 VDD VSS gf180mcu_fd_sc_mcu7t5v0__filltie
XFILLER_94_454 VDD VDD VSS VSS gf180mcu_fd_sc_mcu7t5v0__fill_1
X_2112_ _2112_/I _2185_/A1 VDD VDD VSS VSS gf180mcu_fd_sc_mcu7t5v0__clkinv_1
XFILLER_81_104 VDD VDD VSS VSS gf180mcu_fd_sc_mcu7t5v0__fillcap_8
X_3092_ _3987_/Q _3092_/I1 _4131_/D _3987_/D VDD VDD VSS VSS gf180mcu_fd_sc_mcu7t5v0__mux2_2
X_2043_ place71/Z _2097_/A2 _2097_/A3 _2042_/Z _2045_/A2 VDD VDD VSS VSS gf180mcu_fd_sc_mcu7t5v0__nand4_2
XFILLER_81_137 VDD VDD VSS VSS gf180mcu_fd_sc_mcu7t5v0__fill_2
XFILLER_48_893 VDD VDD VSS VSS gf180mcu_fd_sc_mcu7t5v0__fillcap_4
XFILLER_23_738 VDD VDD VSS VSS gf180mcu_fd_sc_mcu7t5v0__fill_2
XTAP_TAPCELL_ROW_33_711 VDD VSS gf180mcu_fd_sc_mcu7t5v0__filltie
XFILLER_62_384 VDD VDD VSS VSS gf180mcu_fd_sc_mcu7t5v0__fill_1
X_3994_ _3994_/D input92/Z _4028_/CLK _3994_/Q VDD VDD VSS VSS gf180mcu_fd_sc_mcu7t5v0__dffrnq_1
X_2945_ _4039_/Q _3919_/Q _2972_/S _3919_/D VDD VDD VSS VSS gf180mcu_fd_sc_mcu7t5v0__mux2_2
X_2876_ place89/Z _2900_/S _2877_/B VDD VDD VSS VSS gf180mcu_fd_sc_mcu7t5v0__nand2_1
X_1827_ _2903_/A1 _4146_/Q _1827_/Z VDD VDD VSS VSS gf180mcu_fd_sc_mcu7t5v0__xor2_1
XTAP_TAPCELL_ROW_96_1540 VDD VSS gf180mcu_fd_sc_mcu7t5v0__filltie
XFILLER_104_504 VDD VDD VSS VSS gf180mcu_fd_sc_mcu7t5v0__fillcap_16
XFILLER_132_879 VDD VDD VSS VSS gf180mcu_fd_sc_mcu7t5v0__fillcap_4
X_3428_ _4101_/Q _4100_/Q _4099_/Q _3428_/A4 _3429_/A3 VDD VDD VSS VSS gf180mcu_fd_sc_mcu7t5v0__nor4_1
XFILLER_85_410 VDD VDD VSS VSS gf180mcu_fd_sc_mcu7t5v0__fillcap_8
X_3359_ _4081_/Q _3357_/Z _3359_/B _4081_/D VDD VDD VSS VSS gf180mcu_fd_sc_mcu7t5v0__oai21_1
XFILLER_38_37 VDD VDD VSS VSS gf180mcu_fd_sc_mcu7t5v0__fill_2
XFILLER_57_123 VDD VDD VSS VSS gf180mcu_fd_sc_mcu7t5v0__fillcap_16
XFILLER_85_476 VDD VDD VSS VSS gf180mcu_fd_sc_mcu7t5v0__fillcap_4
XFILLER_85_454 VDD VDD VSS VSS gf180mcu_fd_sc_mcu7t5v0__fillcap_8
XFILLER_85_498 VDD VDD VSS VSS gf180mcu_fd_sc_mcu7t5v0__fill_1
XFILLER_26_521 VDD VDD VSS VSS gf180mcu_fd_sc_mcu7t5v0__fillcap_4
XFILLER_72_104 VDD VDD VSS VSS gf180mcu_fd_sc_mcu7t5v0__fill_1
XFILLER_26_543 VDD VDD VSS VSS gf180mcu_fd_sc_mcu7t5v0__fillcap_8
XFILLER_13_204 VDD VDD VSS VSS gf180mcu_fd_sc_mcu7t5v0__fillcap_4
XFILLER_9_208 VDD VDD VSS VSS gf180mcu_fd_sc_mcu7t5v0__fill_2
XTAP_TAPCELL_ROW_101_1599 VDD VSS gf180mcu_fd_sc_mcu7t5v0__filltie
XTAP_TAPCELL_ROW_11_427 VDD VSS gf180mcu_fd_sc_mcu7t5v0__filltie
XFILLER_10_933 VDD VDD VSS VSS gf180mcu_fd_sc_mcu7t5v0__fill_1
XFILLER_127_629 VDD VDD VSS VSS gf180mcu_fd_sc_mcu7t5v0__fill_1
XTAP_TAPCELL_ROW_56_1012 VDD VSS gf180mcu_fd_sc_mcu7t5v0__filltie
XFILLER_122_301 VDD VDD VSS VSS gf180mcu_fd_sc_mcu7t5v0__fillcap_8
XFILLER_123_857 VDD VDD VSS VSS gf180mcu_fd_sc_mcu7t5v0__fillcap_32
XFILLER_122_367 VDD VDD VSS VSS gf180mcu_fd_sc_mcu7t5v0__fill_2
XFILLER_89_782 VDD VDD VSS VSS gf180mcu_fd_sc_mcu7t5v0__fill_1
XFILLER_48_101 VDD VDD VSS VSS gf180mcu_fd_sc_mcu7t5v0__fillcap_4
XFILLER_95_43 VDD VDD VSS VSS gf180mcu_fd_sc_mcu7t5v0__fillcap_8
XFILLER_91_446 VDD VDD VSS VSS gf180mcu_fd_sc_mcu7t5v0__fillcap_4
XTAP_TAPCELL_ROW_19_527 VDD VSS gf180mcu_fd_sc_mcu7t5v0__filltie
XTAP_TAPCELL_ROW_19_538 VDD VSS gf180mcu_fd_sc_mcu7t5v0__filltie
XTAP_TAPCELL_ROW_67_1152 VDD VSS gf180mcu_fd_sc_mcu7t5v0__filltie
XFILLER_44_384 VDD VDD VSS VSS gf180mcu_fd_sc_mcu7t5v0__fill_1
XFILLER_60_811 VDD VDD VSS VSS gf180mcu_fd_sc_mcu7t5v0__fill_2
XTAP_TAPCELL_ROW_67_1163 VDD VSS gf180mcu_fd_sc_mcu7t5v0__filltie
XTAP_TAPCELL_ROW_80_1330 VDD VSS gf180mcu_fd_sc_mcu7t5v0__filltie
XFILLER_71_192 VDD VDD VSS VSS gf180mcu_fd_sc_mcu7t5v0__fill_2
XFILLER_20_719 VDD VDD VSS VSS gf180mcu_fd_sc_mcu7t5v0__fill_1
XFILLER_60_877 VDD VDD VSS VSS gf180mcu_fd_sc_mcu7t5v0__fillcap_8
X_2730_ _4120_/Q _3537_/A1 _2581_/Z place45/I VDD VDD VSS VSS gf180mcu_fd_sc_mcu7t5v0__nor3_1
XTAP_TAPCELL_ROW_119_1838 VDD VSS gf180mcu_fd_sc_mcu7t5v0__filltie
XTAP_TAPCELL_ROW_119_1827 VDD VSS gf180mcu_fd_sc_mcu7t5v0__filltie
XFILLER_8_241 VDD VDD VSS VSS gf180mcu_fd_sc_mcu7t5v0__fillcap_4
X_2661_ _2695_/A2 _2852_/A2 _2676_/S VDD VDD VSS VSS gf180mcu_fd_sc_mcu7t5v0__nand2_4
X_2592_ _3761_/Q place86/Z _2598_/S _3761_/D VDD VDD VSS VSS gf180mcu_fd_sc_mcu7t5v0__mux2_2
XFILLER_113_345 VDD VDD VSS VSS gf180mcu_fd_sc_mcu7t5v0__fillcap_4
X_3213_ _4045_/Q _4013_/Q _4129_/D _4045_/D VDD VDD VSS VSS gf180mcu_fd_sc_mcu7t5v0__mux2_2
XTAP_TAPCELL_ROW_91_1470 VDD VSS gf180mcu_fd_sc_mcu7t5v0__filltie
XFILLER_79_292 VDD VDD VSS VSS gf180mcu_fd_sc_mcu7t5v0__fillcap_32
XFILLER_39_123 VDD VDD VSS VSS gf180mcu_fd_sc_mcu7t5v0__fillcap_16
X_3144_ _4012_/Q _3144_/I1 _3160_/S _4012_/D VDD VDD VSS VSS gf180mcu_fd_sc_mcu7t5v0__mux2_2
X_3075_ _4041_/Q _3978_/Q _3081_/S _3978_/D VDD VDD VSS VSS gf180mcu_fd_sc_mcu7t5v0__mux2_2
XFILLER_55_627 VDD VDD VSS VSS gf180mcu_fd_sc_mcu7t5v0__fill_2
Xaz_v_uart_top_185 s_axi_bresp[1] VDD VDD VSS VSS gf180mcu_fd_sc_mcu7t5v0__tiel
X_2026_ _2097_/A2 _2097_/A3 _2027_/A2 _2028_/A2 VDD VDD VSS VSS gf180mcu_fd_sc_mcu7t5v0__nand3_2
XFILLER_82_457 VDD VDD VSS VSS gf180mcu_fd_sc_mcu7t5v0__fillcap_64
XTAP_TAPCELL_ROW_46_880 VDD VSS gf180mcu_fd_sc_mcu7t5v0__filltie
XFILLER_63_671 VDD VDD VSS VSS gf180mcu_fd_sc_mcu7t5v0__fill_1
XFILLER_35_384 VDD VDD VSS VSS gf180mcu_fd_sc_mcu7t5v0__fillcap_8
XFILLER_62_170 VDD VDD VSS VSS gf180mcu_fd_sc_mcu7t5v0__fillcap_4
X_3977_ _3977_/D _2279_/I _3978_/CLK _3977_/Q VDD VDD VSS VSS gf180mcu_fd_sc_mcu7t5v0__dffrnq_1
XFILLER_50_387 VDD VDD VSS VSS gf180mcu_fd_sc_mcu7t5v0__fillcap_16
X_2859_ place87/Z _3880_/Q _2867_/S _3880_/D VDD VDD VSS VSS gf180mcu_fd_sc_mcu7t5v0__mux2_2
Xhold230 s_axi_awaddr[4] hold230/Z VDD VDD VSS VSS gf180mcu_fd_sc_mcu7t5v0__dlyc_1
XFILLER_131_142 VDD VDD VSS VSS gf180mcu_fd_sc_mcu7t5v0__fillcap_64
XFILLER_104_378 VDD VDD VSS VSS gf180mcu_fd_sc_mcu7t5v0__fillcap_4
XFILLER_49_69 VDD VDD VSS VSS gf180mcu_fd_sc_mcu7t5v0__fill_1
XFILLER_74_925 VDD VDD VSS VSS gf180mcu_fd_sc_mcu7t5v0__fillcap_8
XFILLER_58_454 VDD VDD VSS VSS gf180mcu_fd_sc_mcu7t5v0__fill_1
XFILLER_121_74 VDD VDD VSS VSS gf180mcu_fd_sc_mcu7t5v0__fill_1
XTAP_TAPCELL_ROW_103_1628 VDD VSS gf180mcu_fd_sc_mcu7t5v0__filltie
XFILLER_14_524 VDD VDD VSS VSS gf180mcu_fd_sc_mcu7t5v0__fill_1
XFILLER_42_877 VDD VDD VSS VSS gf180mcu_fd_sc_mcu7t5v0__fillcap_4
XFILLER_14_72 VDD VDD VSS VSS gf180mcu_fd_sc_mcu7t5v0__fill_1
XFILLER_10_730 VDD VDD VSS VSS gf180mcu_fd_sc_mcu7t5v0__fillcap_4
XTAP_TAPCELL_ROW_24_596 VDD VSS gf180mcu_fd_sc_mcu7t5v0__filltie
XTAP_TAPCELL_ROW_62_1093 VDD VSS gf180mcu_fd_sc_mcu7t5v0__filltie
XFILLER_6_734 VDD VDD VSS VSS gf180mcu_fd_sc_mcu7t5v0__fill_1
XFILLER_5_200 VDD VDD VSS VSS gf180mcu_fd_sc_mcu7t5v0__fillcap_8
XFILLER_123_632 VDD VDD VSS VSS gf180mcu_fd_sc_mcu7t5v0__fillcap_16
XTAP_TAPCELL_ROW_114_1768 VDD VSS gf180mcu_fd_sc_mcu7t5v0__filltie
XFILLER_96_527 VDD VDD VSS VSS gf180mcu_fd_sc_mcu7t5v0__fillcap_32
XFILLER_39_80 VDD VDD VSS VSS gf180mcu_fd_sc_mcu7t5v0__fill_2
XFILLER_37_638 VDD VDD VSS VSS gf180mcu_fd_sc_mcu7t5v0__fill_1
XFILLER_37_627 VDD VDD VSS VSS gf180mcu_fd_sc_mcu7t5v0__fill_2
XFILLER_64_457 VDD VDD VSS VSS gf180mcu_fd_sc_mcu7t5v0__fillcap_32
X_3900_ _3900_/D _4148_/RN _4145_/CLK _3900_/Q VDD VDD VSS VSS gf180mcu_fd_sc_mcu7t5v0__dffrnq_1
X_3831_ _3831_/D _3835_/CLK _3831_/Q VDD VDD VSS VSS gf180mcu_fd_sc_mcu7t5v0__dffq_1
XTAP_TAPCELL_ROW_43_850 VDD VSS gf180mcu_fd_sc_mcu7t5v0__filltie
XFILLER_119_905 VDD VDD VSS VSS gf180mcu_fd_sc_mcu7t5v0__fillcap_4
XFILLER_20_527 VDD VDD VSS VSS gf180mcu_fd_sc_mcu7t5v0__fillcap_4
X_3762_ _3762_/D _4076_/CLK _3762_/Q VDD VDD VSS VSS gf180mcu_fd_sc_mcu7t5v0__dffq_1
XFILLER_32_387 VDD VDD VSS VSS gf180mcu_fd_sc_mcu7t5v0__fillcap_64
X_3693_ _3693_/D _3968_/CLK _3693_/Q VDD VDD VSS VSS gf180mcu_fd_sc_mcu7t5v0__dffq_1
X_2644_ place90/Z _3781_/Q _2658_/S _3781_/D VDD VDD VSS VSS gf180mcu_fd_sc_mcu7t5v0__mux2_2
XFILLER_113_142 VDD VDD VSS VSS gf180mcu_fd_sc_mcu7t5v0__fillcap_64
XFILLER_59_207 VDD VDD VSS VSS gf180mcu_fd_sc_mcu7t5v0__fill_2
XFILLER_102_849 VDD VDD VSS VSS gf180mcu_fd_sc_mcu7t5v0__fillcap_16
XFILLER_28_605 VDD VDD VSS VSS gf180mcu_fd_sc_mcu7t5v0__fill_2
X_3127_ _4004_/Q _3127_/I1 _3160_/S _4004_/D VDD VDD VSS VSS gf180mcu_fd_sc_mcu7t5v0__mux2_2
X_3058_ _4051_/Q _3971_/Q _3081_/S _3971_/D VDD VDD VSS VSS gf180mcu_fd_sc_mcu7t5v0__mux2_2
XFILLER_71_928 VDD VDD VSS VSS gf180mcu_fd_sc_mcu7t5v0__fillcap_4
XFILLER_42_107 VDD VDD VSS VSS gf180mcu_fd_sc_mcu7t5v0__fillcap_64
XTAP_TAPCELL_ROW_21_555 VDD VSS gf180mcu_fd_sc_mcu7t5v0__filltie
XFILLER_129_6 VDD VDD VSS VSS gf180mcu_fd_sc_mcu7t5v0__fillcap_8
XFILLER_117_470 VDD VDD VSS VSS gf180mcu_fd_sc_mcu7t5v0__fillcap_4
XFILLER_105_610 VDD VDD VSS VSS gf180mcu_fd_sc_mcu7t5v0__fillcap_8
XFILLER_117_492 VDD VDD VSS VSS gf180mcu_fd_sc_mcu7t5v0__fillcap_16
XFILLER_105_632 VDD VDD VSS VSS gf180mcu_fd_sc_mcu7t5v0__fillcap_4
XFILLER_2_247 VDD VDD VSS VSS gf180mcu_fd_sc_mcu7t5v0__fillcap_4
XFILLER_132_495 VDD VDD VSS VSS gf180mcu_fd_sc_mcu7t5v0__fillcap_8
XFILLER_59_752 VDD VDD VSS VSS gf180mcu_fd_sc_mcu7t5v0__fill_2
XFILLER_86_593 VDD VDD VSS VSS gf180mcu_fd_sc_mcu7t5v0__fill_2
XFILLER_86_571 VDD VDD VSS VSS gf180mcu_fd_sc_mcu7t5v0__fillcap_4
XFILLER_74_733 VDD VDD VSS VSS gf180mcu_fd_sc_mcu7t5v0__fill_2
XFILLER_19_627 VDD VDD VSS VSS gf180mcu_fd_sc_mcu7t5v0__fill_2
XFILLER_19_649 VDD VDD VSS VSS gf180mcu_fd_sc_mcu7t5v0__fillcap_16
Xplace55 place55/I _2556_/S VDD VDD VSS VSS gf180mcu_fd_sc_mcu7t5v0__buf_8
Xplace44 place44/I _2764_/S VDD VDD VSS VSS gf180mcu_fd_sc_mcu7t5v0__buf_8
XFILLER_46_435 VDD VDD VSS VSS gf180mcu_fd_sc_mcu7t5v0__fillcap_8
XFILLER_46_457 VDD VDD VSS VSS gf180mcu_fd_sc_mcu7t5v0__fillcap_16
Xplace66 place66/I _2972_/S VDD VDD VSS VSS gf180mcu_fd_sc_mcu7t5v0__buf_8
Xplace77 _4093_/Q place77/Z VDD VDD VSS VSS gf180mcu_fd_sc_mcu7t5v0__buf_8
XTAP_TAPCELL_ROW_29_666 VDD VSS gf180mcu_fd_sc_mcu7t5v0__filltie
Xplace88 _4023_/Q place88/Z VDD VDD VSS VSS gf180mcu_fd_sc_mcu7t5v0__buf_8
XFILLER_73_298 VDD VDD VSS VSS gf180mcu_fd_sc_mcu7t5v0__fillcap_4
XFILLER_15_833 VDD VDD VSS VSS gf180mcu_fd_sc_mcu7t5v0__fillcap_4
Xclkbuf_leaf_53_clk clkload0/I _3865_/CLK VDD VDD VSS VSS gf180mcu_fd_sc_mcu7t5v0__clkbuf_8
XTAP_TAPCELL_ROW_64_1122 VDD VSS gf180mcu_fd_sc_mcu7t5v0__filltie
XFILLER_15_866 VDD VDD VSS VSS gf180mcu_fd_sc_mcu7t5v0__fillcap_4
XFILLER_14_387 VDD VDD VSS VSS gf180mcu_fd_sc_mcu7t5v0__fill_2
XFILLER_41_162 VDD VDD VSS VSS gf180mcu_fd_sc_mcu7t5v0__fill_2
XFILLER_127_212 VDD VDD VSS VSS gf180mcu_fd_sc_mcu7t5v0__fill_2
XFILLER_6_520 VDD VDD VSS VSS gf180mcu_fd_sc_mcu7t5v0__fillcap_4
XFILLER_128_768 VDD VDD VSS VSS gf180mcu_fd_sc_mcu7t5v0__fillcap_4
XFILLER_10_593 VDD VDD VSS VSS gf180mcu_fd_sc_mcu7t5v0__fill_2
XTAP_TAPCELL_ROW_75_1262 VDD VSS gf180mcu_fd_sc_mcu7t5v0__filltie
XFILLER_6_597 VDD VDD VSS VSS gf180mcu_fd_sc_mcu7t5v0__fillcap_4
X_2360_ _4096_/Q _2360_/A2 _3409_/A2 _2360_/Z VDD VDD VSS VSS gf180mcu_fd_sc_mcu7t5v0__or3_1
XFILLER_69_527 VDD VDD VSS VSS gf180mcu_fd_sc_mcu7t5v0__fillcap_32
XFILLER_110_101 VDD VDD VSS VSS gf180mcu_fd_sc_mcu7t5v0__fillcap_4
X_4030_ _4030_/D _4148_/RN _4138_/CLK _4030_/Q VDD VDD VSS VSS gf180mcu_fd_sc_mcu7t5v0__dffrnq_1
XPHY_EDGE_ROW_10_Right_10 VDD VSS gf180mcu_fd_sc_mcu7t5v0__endcap
XFILLER_2_53 VDD VDD VSS VSS gf180mcu_fd_sc_mcu7t5v0__fillcap_8
XFILLER_38_925 VDD VDD VSS VSS gf180mcu_fd_sc_mcu7t5v0__fillcap_8
XTAP_TAPCELL_ROW_127_1937 VDD VSS gf180mcu_fd_sc_mcu7t5v0__filltie
XFILLER_92_552 VDD VDD VSS VSS gf180mcu_fd_sc_mcu7t5v0__fill_2
XFILLER_53_906 VDD VDD VSS VSS gf180mcu_fd_sc_mcu7t5v0__fillcap_4
XFILLER_65_766 VDD VDD VSS VSS gf180mcu_fd_sc_mcu7t5v0__fillcap_4
XFILLER_24_107 VDD VDD VSS VSS gf180mcu_fd_sc_mcu7t5v0__fill_1
Xclkbuf_leaf_44_clk clkload3/I _4167_/CLK VDD VDD VSS VSS gf180mcu_fd_sc_mcu7t5v0__clkbuf_8
XFILLER_33_696 VDD VDD VSS VSS gf180mcu_fd_sc_mcu7t5v0__fillcap_4
XFILLER_119_702 VDD VDD VSS VSS gf180mcu_fd_sc_mcu7t5v0__fillcap_16
XFILLER_20_346 VDD VDD VSS VSS gf180mcu_fd_sc_mcu7t5v0__fill_1
X_3814_ _3814_/D _4159_/CLK _3814_/Q VDD VDD VSS VSS gf180mcu_fd_sc_mcu7t5v0__dffq_1
XFILLER_21_18 VDD VDD VSS VSS gf180mcu_fd_sc_mcu7t5v0__fill_2
X_3745_ _3745_/D _3755_/CLK _3745_/Q VDD VDD VSS VSS gf180mcu_fd_sc_mcu7t5v0__dffq_1
XFILLER_107_908 VDD VDD VSS VSS gf180mcu_fd_sc_mcu7t5v0__fill_2
X_3676_ _3676_/D _4076_/CLK _3676_/Q VDD VDD VSS VSS gf180mcu_fd_sc_mcu7t5v0__dffq_1
Xoutput143 _1977_/ZN irq VDD VDD VSS VSS gf180mcu_fd_sc_mcu7t5v0__dlyb_1
Xoutput165 _2265_/ZN s_axi_rdata[26] VDD VDD VSS VSS gf180mcu_fd_sc_mcu7t5v0__dlyb_1
Xoutput154 _2245_/ZN s_axi_rdata[16] VDD VDD VSS VSS gf180mcu_fd_sc_mcu7t5v0__dlyb_1
Xoutput176 _2217_/ZN s_axi_rdata[7] VDD VDD VSS VSS gf180mcu_fd_sc_mcu7t5v0__dlyb_1
XFILLER_114_451 VDD VDD VSS VSS gf180mcu_fd_sc_mcu7t5v0__fillcap_4
X_2558_ _2558_/A1 _2360_/Z place48/I VDD VDD VSS VSS gf180mcu_fd_sc_mcu7t5v0__nor2_1
X_2489_ _3717_/Q place82/Z _2503_/S _3717_/D VDD VDD VSS VSS gf180mcu_fd_sc_mcu7t5v0__mux2_2
XPHY_EDGE_ROW_106_Right_106 VDD VSS gf180mcu_fd_sc_mcu7t5v0__endcap
XFILLER_83_552 VDD VDD VSS VSS gf180mcu_fd_sc_mcu7t5v0__fillcap_8
X_4159_ _4159_/D input92/Z _4159_/CLK _4159_/Q VDD VDD VSS VSS gf180mcu_fd_sc_mcu7t5v0__dffsnq_1
XFILLER_28_457 VDD VDD VSS VSS gf180mcu_fd_sc_mcu7t5v0__fillcap_16
XFILLER_46_37 VDD VDD VSS VSS gf180mcu_fd_sc_mcu7t5v0__fillcap_8
XFILLER_83_574 VDD VDD VSS VSS gf180mcu_fd_sc_mcu7t5v0__fill_2
XFILLER_71_714 VDD VDD VSS VSS gf180mcu_fd_sc_mcu7t5v0__fill_2
XFILLER_55_276 VDD VDD VSS VSS gf180mcu_fd_sc_mcu7t5v0__fillcap_4
XTAP_TAPCELL_ROW_26_625 VDD VSS gf180mcu_fd_sc_mcu7t5v0__filltie
XTAP_TAPCELL_ROW_54_989 VDD VSS gf180mcu_fd_sc_mcu7t5v0__filltie
Xclkbuf_leaf_35_clk clkload3/I _4108_/CLK VDD VDD VSS VSS gf180mcu_fd_sc_mcu7t5v0__clkbuf_8
XFILLER_62_69 VDD VDD VSS VSS gf180mcu_fd_sc_mcu7t5v0__fillcap_4
XFILLER_8_807 VDD VDD VSS VSS gf180mcu_fd_sc_mcu7t5v0__fillcap_64
XFILLER_11_368 VDD VDD VSS VSS gf180mcu_fd_sc_mcu7t5v0__fillcap_4
XFILLER_109_289 VDD VDD VSS VSS gf180mcu_fd_sc_mcu7t5v0__fillcap_32
XTAP_TAPCELL_ROW_111_1727 VDD VSS gf180mcu_fd_sc_mcu7t5v0__filltie
XFILLER_3_556 VDD VDD VSS VSS gf180mcu_fd_sc_mcu7t5v0__fillcap_4
XFILLER_105_473 VDD VDD VSS VSS gf180mcu_fd_sc_mcu7t5v0__fill_2
XFILLER_79_836 VDD VDD VSS VSS gf180mcu_fd_sc_mcu7t5v0__fillcap_4
XFILLER_120_454 VDD VDD VSS VSS gf180mcu_fd_sc_mcu7t5v0__fill_1
XTAP_TAPCELL_ROW_6_361 VDD VSS gf180mcu_fd_sc_mcu7t5v0__filltie
XTAP_TAPCELL_ROW_70_1192 VDD VSS gf180mcu_fd_sc_mcu7t5v0__filltie
XFILLER_47_744 VDD VDD VSS VSS gf180mcu_fd_sc_mcu7t5v0__fillcap_16
XFILLER_46_254 VDD VDD VSS VSS gf180mcu_fd_sc_mcu7t5v0__fillcap_16
Xclkbuf_leaf_26_clk clkload6/I _3981_/CLK VDD VDD VSS VSS gf180mcu_fd_sc_mcu7t5v0__clkbuf_8
XFILLER_50_909 VDD VDD VSS VSS gf180mcu_fd_sc_mcu7t5v0__fillcap_16
XTAP_TAPCELL_ROW_122_1878 VDD VSS gf180mcu_fd_sc_mcu7t5v0__filltie
XTAP_TAPCELL_ROW_122_1867 VDD VSS gf180mcu_fd_sc_mcu7t5v0__filltie
XFILLER_61_279 VDD VDD VSS VSS gf180mcu_fd_sc_mcu7t5v0__fill_1
X_1860_ _3887_/Q _2879_/A1 VDD VDD VSS VSS gf180mcu_fd_sc_mcu7t5v0__clkinv_1
X_3461_ _4104_/Q _4148_/Q _3477_/A2 _3462_/B VDD VDD VSS VSS gf180mcu_fd_sc_mcu7t5v0__nand3_1
X_3392_ _3391_/B _3390_/Z _3392_/B _4089_/D VDD VDD VSS VSS gf180mcu_fd_sc_mcu7t5v0__oai21_2
X_2412_ _4074_/Q _3684_/Q _2412_/S _3684_/D VDD VDD VSS VSS gf180mcu_fd_sc_mcu7t5v0__mux2_2
XFILLER_112_933 VDD VDD VSS VSS gf180mcu_fd_sc_mcu7t5v0__fill_1
X_2343_ _3653_/Q place82/Z _2357_/S _3653_/D VDD VDD VSS VSS gf180mcu_fd_sc_mcu7t5v0__mux2_2
XFILLER_35_2 VDD VDD VSS VSS gf180mcu_fd_sc_mcu7t5v0__fillcap_64
XFILLER_69_368 VDD VDD VSS VSS gf180mcu_fd_sc_mcu7t5v0__fill_2
X_2274_ _3932_/Q place72/Z place63/Z _3964_/Q _3972_/Q place67/Z _2275_/I VDD VDD
+ VSS VSS gf180mcu_fd_sc_mcu7t5v0__aoi222_1
X_4013_ _4013_/D input92/Z _4045_/CLK _4013_/Q VDD VDD VSS VSS gf180mcu_fd_sc_mcu7t5v0__dffrnq_1
XFILLER_97_699 VDD VDD VSS VSS gf180mcu_fd_sc_mcu7t5v0__fill_1
XTAP_TAPCELL_ROW_88_1431 VDD VSS gf180mcu_fd_sc_mcu7t5v0__filltie
XFILLER_25_416 VDD VDD VSS VSS gf180mcu_fd_sc_mcu7t5v0__fillcap_4
XFILLER_26_928 VDD VDD VSS VSS gf180mcu_fd_sc_mcu7t5v0__fillcap_4
XFILLER_53_725 VDD VDD VSS VSS gf180mcu_fd_sc_mcu7t5v0__fill_2
XFILLER_65_552 VDD VDD VSS VSS gf180mcu_fd_sc_mcu7t5v0__fill_2
Xclkbuf_leaf_17_clk clkload2/I _4145_/CLK VDD VDD VSS VSS gf180mcu_fd_sc_mcu7t5v0__clkbuf_8
XFILLER_80_577 VDD VDD VSS VSS gf180mcu_fd_sc_mcu7t5v0__fillcap_16
XFILLER_53_769 VDD VDD VSS VSS gf180mcu_fd_sc_mcu7t5v0__fill_1
XTAP_TAPCELL_ROW_51_948 VDD VSS gf180mcu_fd_sc_mcu7t5v0__filltie
XFILLER_52_279 VDD VDD VSS VSS gf180mcu_fd_sc_mcu7t5v0__fillcap_16
X_1989_ _1993_/C _1993_/A1 _1993_/A2 _4089_/Q _1995_/A1 VDD VDD VSS VSS gf180mcu_fd_sc_mcu7t5v0__oai31_1
XTAP_TAPCELL_ROW_99_1571 VDD VSS gf180mcu_fd_sc_mcu7t5v0__filltie
XFILLER_21_699 VDD VDD VSS VSS gf180mcu_fd_sc_mcu7t5v0__fill_1
XTAP_TAPCELL_ROW_31_683 VDD VSS gf180mcu_fd_sc_mcu7t5v0__filltie
XTAP_TAPCELL_ROW_31_694 VDD VSS gf180mcu_fd_sc_mcu7t5v0__filltie
X_3728_ _3728_/D _3738_/CLK _3728_/Q VDD VDD VSS VSS gf180mcu_fd_sc_mcu7t5v0__dffq_1
X_3659_ _3659_/D _3732_/CLK _3659_/Q VDD VDD VSS VSS gf180mcu_fd_sc_mcu7t5v0__dffq_1
XFILLER_87_154 VDD VDD VSS VSS gf180mcu_fd_sc_mcu7t5v0__fill_2
XFILLER_76_839 VDD VDD VSS VSS gf180mcu_fd_sc_mcu7t5v0__fillcap_4
XTAP_TAPCELL_ROW_3_320 VDD VSS gf180mcu_fd_sc_mcu7t5v0__filltie
XFILLER_75_349 VDD VDD VSS VSS gf180mcu_fd_sc_mcu7t5v0__fill_1
XTAP_TAPCELL_ROW_3_331 VDD VSS gf180mcu_fd_sc_mcu7t5v0__filltie
XFILLER_28_221 VDD VDD VSS VSS gf180mcu_fd_sc_mcu7t5v0__fill_2
XFILLER_113_64 VDD VDD VSS VSS gf180mcu_fd_sc_mcu7t5v0__fillcap_4
XFILLER_28_243 VDD VDD VSS VSS gf180mcu_fd_sc_mcu7t5v0__fill_2
XFILLER_56_563 VDD VDD VSS VSS gf180mcu_fd_sc_mcu7t5v0__fill_1
XFILLER_83_393 VDD VDD VSS VSS gf180mcu_fd_sc_mcu7t5v0__fillcap_8
XFILLER_71_522 VDD VDD VSS VSS gf180mcu_fd_sc_mcu7t5v0__fill_1
XTAP_TAPCELL_ROW_39_794 VDD VSS gf180mcu_fd_sc_mcu7t5v0__filltie
XFILLER_43_224 VDD VDD VSS VSS gf180mcu_fd_sc_mcu7t5v0__fill_2
XFILLER_43_279 VDD VDD VSS VSS gf180mcu_fd_sc_mcu7t5v0__fill_1
XFILLER_51_290 VDD VDD VSS VSS gf180mcu_fd_sc_mcu7t5v0__fill_1
XFILLER_7_136 VDD VDD VSS VSS gf180mcu_fd_sc_mcu7t5v0__fillcap_4
XFILLER_125_524 VDD VDD VSS VSS gf180mcu_fd_sc_mcu7t5v0__fillcap_16
XFILLER_99_909 VDD VDD VSS VSS gf180mcu_fd_sc_mcu7t5v0__fill_1
XTAP_TAPCELL_ROW_59_1054 VDD VSS gf180mcu_fd_sc_mcu7t5v0__filltie
XFILLER_3_375 VDD VDD VSS VSS gf180mcu_fd_sc_mcu7t5v0__fill_1
XTAP_TAPCELL_ROW_72_1221 VDD VSS gf180mcu_fd_sc_mcu7t5v0__filltie
XFILLER_67_806 VDD VDD VSS VSS gf180mcu_fd_sc_mcu7t5v0__fillcap_32
XFILLER_35_747 VDD VDD VSS VSS gf180mcu_fd_sc_mcu7t5v0__fillcap_16
XTAP_TAPCELL_ROW_83_1361 VDD VSS gf180mcu_fd_sc_mcu7t5v0__filltie
X_1912_ _1888_/B _1913_/B2 _1914_/B1 VDD VDD VSS VSS gf180mcu_fd_sc_mcu7t5v0__nand2_1
X_2892_ _3894_/Q _4030_/Q _2900_/S _3894_/D VDD VDD VSS VSS gf180mcu_fd_sc_mcu7t5v0__mux2_2
X_1843_ _1949_/A1 _1949_/A2 _1843_/Z VDD VDD VSS VSS gf180mcu_fd_sc_mcu7t5v0__or2_4
XFILLER_129_885 VDD VDD VSS VSS gf180mcu_fd_sc_mcu7t5v0__fill_2
XFILLER_128_362 VDD VDD VSS VSS gf180mcu_fd_sc_mcu7t5v0__fillcap_16
XFILLER_128_384 VDD VDD VSS VSS gf180mcu_fd_sc_mcu7t5v0__fill_1
X_3513_ _4112_/Q _3506_/Z _3501_/Z _3516_/A3 _3516_/A2 _3514_/A2 VDD VDD VSS VSS gf180mcu_fd_sc_mcu7t5v0__oai32_1
XFILLER_89_408 VDD VDD VSS VSS gf180mcu_fd_sc_mcu7t5v0__fillcap_8
X_3444_ _3444_/A1 _3444_/A2 _4101_/Q _3445_/B VDD VDD VSS VSS gf180mcu_fd_sc_mcu7t5v0__oai21_1
Xclkbuf_leaf_6_clk clkload0/I _4148_/CLK VDD VDD VSS VSS gf180mcu_fd_sc_mcu7t5v0__clkbuf_8
X_3375_ _1968_/I _3375_/A2 _3375_/A3 _3394_/A4 VDD VDD VSS VSS gf180mcu_fd_sc_mcu7t5v0__nand3_2
XFILLER_85_625 VDD VDD VSS VSS gf180mcu_fd_sc_mcu7t5v0__fillcap_4
X_2326_ _4068_/Q _3646_/Q _2338_/S _3646_/D VDD VDD VSS VSS gf180mcu_fd_sc_mcu7t5v0__mux2_2
X_2257_ _2257_/I _2257_/ZN VDD VDD VSS VSS gf180mcu_fd_sc_mcu7t5v0__inv_1
XFILLER_26_714 VDD VDD VSS VSS gf180mcu_fd_sc_mcu7t5v0__fillcap_16
X_2188_ _3634_/Q _3690_/Q _3698_/Q _3706_/Q place79/Z place78/Z _2188_/Z VDD VDD VSS
+ VSS gf180mcu_fd_sc_mcu7t5v0__mux4_1
XFILLER_81_842 VDD VDD VSS VSS gf180mcu_fd_sc_mcu7t5v0__fillcap_64
XFILLER_38_585 VDD VDD VSS VSS gf180mcu_fd_sc_mcu7t5v0__fillcap_8
XTAP_TAPCELL_ROW_36_753 VDD VSS gf180mcu_fd_sc_mcu7t5v0__filltie
XFILLER_13_419 VDD VDD VSS VSS gf180mcu_fd_sc_mcu7t5v0__fill_1
XFILLER_40_205 VDD VDD VSS VSS gf180mcu_fd_sc_mcu7t5v0__fill_2
XFILLER_21_430 VDD VDD VSS VSS gf180mcu_fd_sc_mcu7t5v0__fillcap_4
XFILLER_21_463 VDD VDD VSS VSS gf180mcu_fd_sc_mcu7t5v0__fillcap_8
XFILLER_107_524 VDD VDD VSS VSS gf180mcu_fd_sc_mcu7t5v0__fillcap_16
XFILLER_4_139 VDD VDD VSS VSS gf180mcu_fd_sc_mcu7t5v0__fillcap_16
XFILLER_122_527 VDD VDD VSS VSS gf180mcu_fd_sc_mcu7t5v0__fillcap_8
XFILLER_0_301 VDD VDD VSS VSS gf180mcu_fd_sc_mcu7t5v0__fillcap_4
XFILLER_130_593 VDD VDD VSS VSS gf180mcu_fd_sc_mcu7t5v0__fill_2
XFILLER_72_831 VDD VDD VSS VSS gf180mcu_fd_sc_mcu7t5v0__fillcap_4
XTAP_TAPCELL_ROW_106_1659 VDD VSS gf180mcu_fd_sc_mcu7t5v0__filltie
XFILLER_17_769 VDD VDD VSS VSS gf180mcu_fd_sc_mcu7t5v0__fill_1
XFILLER_17_72 VDD VDD VSS VSS gf180mcu_fd_sc_mcu7t5v0__fillcap_32
XFILLER_71_352 VDD VDD VSS VSS gf180mcu_fd_sc_mcu7t5v0__fillcap_64
XFILLER_72_897 VDD VDD VSS VSS gf180mcu_fd_sc_mcu7t5v0__fill_2
XFILLER_13_931 VDD VDD VSS VSS gf180mcu_fd_sc_mcu7t5v0__fill_2
XTAP_TAPCELL_ROW_14_469 VDD VSS gf180mcu_fd_sc_mcu7t5v0__filltie
XFILLER_8_445 VDD VDD VSS VSS gf180mcu_fd_sc_mcu7t5v0__fillcap_8
XFILLER_69_8 VDD VDD VSS VSS gf180mcu_fd_sc_mcu7t5v0__fill_1
XFILLER_126_877 VDD VDD VSS VSS gf180mcu_fd_sc_mcu7t5v0__fillcap_32
XFILLER_4_651 VDD VDD VSS VSS gf180mcu_fd_sc_mcu7t5v0__fillcap_8
XFILLER_125_376 VDD VDD VSS VSS gf180mcu_fd_sc_mcu7t5v0__fillcap_4
XFILLER_4_695 VDD VDD VSS VSS gf180mcu_fd_sc_mcu7t5v0__fillcap_32
XTAP_TAPCELL_ROW_130_1977 VDD VSS gf180mcu_fd_sc_mcu7t5v0__filltie
X_3160_ _4020_/Q _3160_/I1 _3160_/S _4020_/D VDD VDD VSS VSS gf180mcu_fd_sc_mcu7t5v0__mux2_2
XFILLER_95_912 VDD VDD VSS VSS gf180mcu_fd_sc_mcu7t5v0__fillcap_16
XFILLER_79_474 VDD VDD VSS VSS gf180mcu_fd_sc_mcu7t5v0__fillcap_16
XFILLER_66_102 VDD VDD VSS VSS gf180mcu_fd_sc_mcu7t5v0__fill_2
XFILLER_121_593 VDD VDD VSS VSS gf180mcu_fd_sc_mcu7t5v0__fillcap_4
X_2111_ _2112_/I _2181_/A3 _2177_/A2 VDD VDD VSS VSS gf180mcu_fd_sc_mcu7t5v0__nor2_1
X_2042_ _4137_/Q _2051_/A3 _2042_/Z VDD VDD VSS VSS gf180mcu_fd_sc_mcu7t5v0__xor2_1
XFILLER_48_872 VDD VDD VSS VSS gf180mcu_fd_sc_mcu7t5v0__fill_2
XFILLER_81_116 VDD VDD VSS VSS gf180mcu_fd_sc_mcu7t5v0__fill_2
XFILLER_35_566 VDD VDD VSS VSS gf180mcu_fd_sc_mcu7t5v0__fill_2
XFILLER_63_842 VDD VDD VSS VSS gf180mcu_fd_sc_mcu7t5v0__fillcap_64
XPHY_EDGE_ROW_8_Right_8 VDD VSS gf180mcu_fd_sc_mcu7t5v0__endcap
XTAP_TAPCELL_ROW_33_712 VDD VSS gf180mcu_fd_sc_mcu7t5v0__filltie
XFILLER_35_577 VDD VDD VSS VSS gf180mcu_fd_sc_mcu7t5v0__fillcap_4
X_3993_ _3993_/D _4148_/RN _4057_/CLK _3993_/Q VDD VDD VSS VSS gf180mcu_fd_sc_mcu7t5v0__dffrnq_1
XFILLER_22_238 VDD VDD VSS VSS gf180mcu_fd_sc_mcu7t5v0__fillcap_4
XFILLER_15_290 VDD VDD VSS VSS gf180mcu_fd_sc_mcu7t5v0__fillcap_4
XFILLER_31_772 VDD VDD VSS VSS gf180mcu_fd_sc_mcu7t5v0__fillcap_8
X_2875_ _2875_/A1 _2900_/S _2875_/B _3885_/D VDD VDD VSS VSS gf180mcu_fd_sc_mcu7t5v0__oai21_1
X_1826_ _3899_/Q _2903_/A1 VDD VDD VSS VSS gf180mcu_fd_sc_mcu7t5v0__inv_3
XFILLER_129_693 VDD VDD VSS VSS gf180mcu_fd_sc_mcu7t5v0__fill_2
XTAP_TAPCELL_ROW_96_1530 VDD VSS gf180mcu_fd_sc_mcu7t5v0__filltie
XFILLER_117_888 VDD VDD VSS VSS gf180mcu_fd_sc_mcu7t5v0__fillcap_4
XFILLER_116_387 VDD VDD VSS VSS gf180mcu_fd_sc_mcu7t5v0__fillcap_16
XFILLER_104_527 VDD VDD VSS VSS gf180mcu_fd_sc_mcu7t5v0__fillcap_64
XFILLER_131_346 VDD VDD VSS VSS gf180mcu_fd_sc_mcu7t5v0__fillcap_4
XPHY_EDGE_ROW_39_Right_39 VDD VSS gf180mcu_fd_sc_mcu7t5v0__endcap
X_3427_ _3908_/Q _3428_/A4 VDD VDD VSS VSS gf180mcu_fd_sc_mcu7t5v0__clkinv_1
XFILLER_98_761 VDD VDD VSS VSS gf180mcu_fd_sc_mcu7t5v0__fill_2
XFILLER_97_260 VDD VDD VSS VSS gf180mcu_fd_sc_mcu7t5v0__fillcap_8
XFILLER_86_912 VDD VDD VSS VSS gf180mcu_fd_sc_mcu7t5v0__fillcap_16
X_3358_ _4081_/Q _3370_/A1 _3359_/B VDD VDD VSS VSS gf180mcu_fd_sc_mcu7t5v0__nand2_1
XFILLER_97_282 VDD VDD VSS VSS gf180mcu_fd_sc_mcu7t5v0__fillcap_32
XFILLER_85_422 VDD VDD VSS VSS gf180mcu_fd_sc_mcu7t5v0__fillcap_32
X_2309_ _3639_/Q _4069_/Q _2319_/S _3639_/D VDD VDD VSS VSS gf180mcu_fd_sc_mcu7t5v0__mux2_2
X_3289_ _4161_/Q _4163_/Q _3289_/Z VDD VDD VSS VSS gf180mcu_fd_sc_mcu7t5v0__xor2_1
XFILLER_26_555 VDD VDD VSS VSS gf180mcu_fd_sc_mcu7t5v0__fill_2
XFILLER_53_341 VDD VDD VSS VSS gf180mcu_fd_sc_mcu7t5v0__fillcap_8
XFILLER_80_193 VDD VDD VSS VSS gf180mcu_fd_sc_mcu7t5v0__fillcap_8
XFILLER_41_558 VDD VDD VSS VSS gf180mcu_fd_sc_mcu7t5v0__fill_2
XPHY_EDGE_ROW_48_Right_48 VDD VSS gf180mcu_fd_sc_mcu7t5v0__endcap
XFILLER_53_396 VDD VDD VSS VSS gf180mcu_fd_sc_mcu7t5v0__fill_2
XTAP_TAPCELL_ROW_11_428 VDD VSS gf180mcu_fd_sc_mcu7t5v0__filltie
XFILLER_21_282 VDD VDD VSS VSS gf180mcu_fd_sc_mcu7t5v0__fillcap_64
XFILLER_126_107 VDD VDD VSS VSS gf180mcu_fd_sc_mcu7t5v0__fillcap_4
XFILLER_119_170 VDD VDD VSS VSS gf180mcu_fd_sc_mcu7t5v0__fill_2
XFILLER_5_426 VDD VDD VSS VSS gf180mcu_fd_sc_mcu7t5v0__fill_2
XFILLER_108_877 VDD VDD VSS VSS gf180mcu_fd_sc_mcu7t5v0__fillcap_8
XFILLER_107_343 VDD VDD VSS VSS gf180mcu_fd_sc_mcu7t5v0__fillcap_4
XTAP_TAPCELL_ROW_56_1013 VDD VSS gf180mcu_fd_sc_mcu7t5v0__filltie
XFILLER_123_836 VDD VDD VSS VSS gf180mcu_fd_sc_mcu7t5v0__fillcap_4
XFILLER_122_313 VDD VDD VSS VSS gf180mcu_fd_sc_mcu7t5v0__fill_2
XPHY_EDGE_ROW_57_Right_57 VDD VSS gf180mcu_fd_sc_mcu7t5v0__endcap
XFILLER_122_335 VDD VDD VSS VSS gf180mcu_fd_sc_mcu7t5v0__fillcap_8
XFILLER_1_632 VDD VDD VSS VSS gf180mcu_fd_sc_mcu7t5v0__fillcap_64
XFILLER_89_772 VDD VDD VSS VSS gf180mcu_fd_sc_mcu7t5v0__fillcap_8
XFILLER_77_912 VDD VDD VSS VSS gf180mcu_fd_sc_mcu7t5v0__fillcap_16
XTAP_TAPCELL_ROW_19_528 VDD VSS gf180mcu_fd_sc_mcu7t5v0__filltie
XTAP_TAPCELL_ROW_19_539 VDD VSS gf180mcu_fd_sc_mcu7t5v0__filltie
XFILLER_44_330 VDD VDD VSS VSS gf180mcu_fd_sc_mcu7t5v0__fillcap_4
XFILLER_45_842 VDD VDD VSS VSS gf180mcu_fd_sc_mcu7t5v0__fillcap_64
XFILLER_72_661 VDD VDD VSS VSS gf180mcu_fd_sc_mcu7t5v0__fillcap_4
XTAP_TAPCELL_ROW_67_1153 VDD VSS gf180mcu_fd_sc_mcu7t5v0__filltie
XPHY_EDGE_ROW_66_Right_66 VDD VSS gf180mcu_fd_sc_mcu7t5v0__endcap
XTAP_TAPCELL_ROW_80_1320 VDD VSS gf180mcu_fd_sc_mcu7t5v0__filltie
XTAP_TAPCELL_ROW_80_1331 VDD VSS gf180mcu_fd_sc_mcu7t5v0__filltie
XFILLER_13_772 VDD VDD VSS VSS gf180mcu_fd_sc_mcu7t5v0__fillcap_64
XTAP_TAPCELL_ROW_119_1839 VDD VSS gf180mcu_fd_sc_mcu7t5v0__filltie
XTAP_TAPCELL_ROW_119_1828 VDD VSS gf180mcu_fd_sc_mcu7t5v0__filltie
XFILLER_118_619 VDD VDD VSS VSS gf180mcu_fd_sc_mcu7t5v0__fillcap_4
XFILLER_40_591 VDD VDD VSS VSS gf180mcu_fd_sc_mcu7t5v0__fillcap_4
X_2660_ _2748_/A1 _4121_/Q _2852_/A2 VDD VDD VSS VSS gf180mcu_fd_sc_mcu7t5v0__nor2_1
XFILLER_60_91 VDD VDD VSS VSS gf180mcu_fd_sc_mcu7t5v0__fillcap_8
XPHY_EDGE_ROW_75_Right_75 VDD VSS gf180mcu_fd_sc_mcu7t5v0__endcap
XTAP_TAPCELL_ROW_91_1471 VDD VSS gf180mcu_fd_sc_mcu7t5v0__filltie
XFILLER_67_400 VDD VDD VSS VSS gf180mcu_fd_sc_mcu7t5v0__fillcap_8
XFILLER_79_282 VDD VDD VSS VSS gf180mcu_fd_sc_mcu7t5v0__fillcap_4
XFILLER_27_308 VDD VDD VSS VSS gf180mcu_fd_sc_mcu7t5v0__fill_1
XFILLER_67_466 VDD VDD VSS VSS gf180mcu_fd_sc_mcu7t5v0__fillcap_16
XFILLER_94_296 VDD VDD VSS VSS gf180mcu_fd_sc_mcu7t5v0__fillcap_4
XFILLER_94_263 VDD VDD VSS VSS gf180mcu_fd_sc_mcu7t5v0__fillcap_4
XPHY_EDGE_ROW_84_Right_84 VDD VSS gf180mcu_fd_sc_mcu7t5v0__endcap
XFILLER_82_403 VDD VDD VSS VSS gf180mcu_fd_sc_mcu7t5v0__fill_2
Xaz_v_uart_top_186 s_axi_rresp[0] VDD VDD VSS VSS gf180mcu_fd_sc_mcu7t5v0__tiel
X_2025_ _2013_/Z _2024_/Z _2027_/A2 VDD VDD VSS VSS gf180mcu_fd_sc_mcu7t5v0__nor2_1
XFILLER_35_330 VDD VDD VSS VSS gf180mcu_fd_sc_mcu7t5v0__fillcap_4
XFILLER_70_609 VDD VDD VSS VSS gf180mcu_fd_sc_mcu7t5v0__fill_1
XFILLER_35_352 VDD VDD VSS VSS gf180mcu_fd_sc_mcu7t5v0__fillcap_32
XTAP_TAPCELL_ROW_46_881 VDD VSS gf180mcu_fd_sc_mcu7t5v0__filltie
XFILLER_50_311 VDD VDD VSS VSS gf180mcu_fd_sc_mcu7t5v0__fillcap_4
X_3976_ _3976_/D _2279_/I _3976_/CLK _3976_/Q VDD VDD VSS VSS gf180mcu_fd_sc_mcu7t5v0__dffrnq_1
XFILLER_50_355 VDD VDD VSS VSS gf180mcu_fd_sc_mcu7t5v0__fill_1
XFILLER_10_219 VDD VDD VSS VSS gf180mcu_fd_sc_mcu7t5v0__fillcap_4
XPHY_EDGE_ROW_93_Right_93 VDD VSS gf180mcu_fd_sc_mcu7t5v0__endcap
X_1809_ _3887_/Q _3888_/Q _3885_/Q _3886_/Q _1935_/A4 VDD VDD VSS VSS gf180mcu_fd_sc_mcu7t5v0__nor4_4
Xhold220 s_axi_wdata[8] hold220/Z VDD VDD VSS VSS gf180mcu_fd_sc_mcu7t5v0__dlyc_1
X_2789_ place88/Z _3847_/Q _2799_/S _3847_/D VDD VDD VSS VSS gf180mcu_fd_sc_mcu7t5v0__mux2_2
XFILLER_117_696 VDD VDD VSS VSS gf180mcu_fd_sc_mcu7t5v0__fillcap_4
XFILLER_116_173 VDD VDD VSS VSS gf180mcu_fd_sc_mcu7t5v0__fill_2
XFILLER_105_836 VDD VDD VSS VSS gf180mcu_fd_sc_mcu7t5v0__fillcap_4
Xhold231 s_axi_awaddr[3] hold231/Z VDD VDD VSS VSS gf180mcu_fd_sc_mcu7t5v0__dlyc_1
XFILLER_132_699 VDD VDD VSS VSS gf180mcu_fd_sc_mcu7t5v0__fillcap_8
XFILLER_59_912 VDD VDD VSS VSS gf180mcu_fd_sc_mcu7t5v0__fillcap_16
XFILLER_86_731 VDD VDD VSS VSS gf180mcu_fd_sc_mcu7t5v0__fillcap_4
XFILLER_85_263 VDD VDD VSS VSS gf180mcu_fd_sc_mcu7t5v0__fill_2
XFILLER_58_488 VDD VDD VSS VSS gf180mcu_fd_sc_mcu7t5v0__fillcap_16
XFILLER_27_842 VDD VDD VSS VSS gf180mcu_fd_sc_mcu7t5v0__fillcap_8
XFILLER_65_69 VDD VDD VSS VSS gf180mcu_fd_sc_mcu7t5v0__fill_1
XFILLER_121_42 VDD VDD VSS VSS gf180mcu_fd_sc_mcu7t5v0__fillcap_16
XFILLER_42_801 VDD VDD VSS VSS gf180mcu_fd_sc_mcu7t5v0__fillcap_4
XTAP_TAPCELL_ROW_103_1629 VDD VSS gf180mcu_fd_sc_mcu7t5v0__filltie
XTAP_TAPCELL_ROW_24_597 VDD VSS gf180mcu_fd_sc_mcu7t5v0__filltie
XTAP_TAPCELL_ROW_62_1094 VDD VSS gf180mcu_fd_sc_mcu7t5v0__filltie
XFILLER_10_786 VDD VDD VSS VSS gf180mcu_fd_sc_mcu7t5v0__fillcap_16
XFILLER_5_212 VDD VDD VSS VSS gf180mcu_fd_sc_mcu7t5v0__fillcap_64
XFILLER_108_663 VDD VDD VSS VSS gf180mcu_fd_sc_mcu7t5v0__fill_2
XTAP_TAPCELL_ROW_114_1769 VDD VSS gf180mcu_fd_sc_mcu7t5v0__filltie
XFILLER_1_440 VDD VDD VSS VSS gf180mcu_fd_sc_mcu7t5v0__fill_1
XFILLER_77_753 VDD VDD VSS VSS gf180mcu_fd_sc_mcu7t5v0__fillcap_16
XFILLER_76_241 VDD VDD VSS VSS gf180mcu_fd_sc_mcu7t5v0__fillcap_4
XFILLER_64_403 VDD VDD VSS VSS gf180mcu_fd_sc_mcu7t5v0__fillcap_8
XFILLER_92_789 VDD VDD VSS VSS gf180mcu_fd_sc_mcu7t5v0__fill_2
XFILLER_91_266 VDD VDD VSS VSS gf180mcu_fd_sc_mcu7t5v0__fillcap_4
XFILLER_17_352 VDD VDD VSS VSS gf180mcu_fd_sc_mcu7t5v0__fillcap_64
XFILLER_18_897 VDD VDD VSS VSS gf180mcu_fd_sc_mcu7t5v0__fill_2
X_3830_ _3830_/D _4153_/CLK _3830_/Q VDD VDD VSS VSS gf180mcu_fd_sc_mcu7t5v0__dffq_1
XTAP_TAPCELL_ROW_43_840 VDD VSS gf180mcu_fd_sc_mcu7t5v0__filltie
XTAP_TAPCELL_ROW_43_851 VDD VSS gf180mcu_fd_sc_mcu7t5v0__filltie
XFILLER_44_193 VDD VDD VSS VSS gf180mcu_fd_sc_mcu7t5v0__fillcap_8
XFILLER_60_664 VDD VDD VSS VSS gf180mcu_fd_sc_mcu7t5v0__fill_1
X_3761_ _3761_/D _3835_/CLK _3761_/Q VDD VDD VSS VSS gf180mcu_fd_sc_mcu7t5v0__dffq_1
XFILLER_119_928 VDD VDD VSS VSS gf180mcu_fd_sc_mcu7t5v0__fillcap_4
XFILLER_9_562 VDD VDD VSS VSS gf180mcu_fd_sc_mcu7t5v0__fillcap_64
X_2712_ _2748_/A1 _4121_/Q _2581_/Z place46/I VDD VDD VSS VSS gf180mcu_fd_sc_mcu7t5v0__nor3_2
X_3692_ _3692_/D _3732_/CLK _3692_/Q VDD VDD VSS VSS gf180mcu_fd_sc_mcu7t5v0__dffq_1
XTAP_TAPCELL_ROW_93_1500 VDD VSS gf180mcu_fd_sc_mcu7t5v0__filltie
X_2643_ _2835_/A1 _2695_/A2 _2658_/S VDD VDD VSS VSS gf180mcu_fd_sc_mcu7t5v0__nand2_4
XFILLER_65_2 VDD VDD VSS VSS gf180mcu_fd_sc_mcu7t5v0__fillcap_8
X_2574_ _3756_/Q _4074_/Q _2574_/S _3756_/D VDD VDD VSS VSS gf180mcu_fd_sc_mcu7t5v0__mux2_2
XFILLER_99_322 VDD VDD VSS VSS gf180mcu_fd_sc_mcu7t5v0__fillcap_16
XFILLER_101_316 VDD VDD VSS VSS gf180mcu_fd_sc_mcu7t5v0__fill_1
XFILLER_19_18 VDD VDD VSS VSS gf180mcu_fd_sc_mcu7t5v0__fillcap_8
XFILLER_101_349 VDD VDD VSS VSS gf180mcu_fd_sc_mcu7t5v0__fill_1
XFILLER_68_753 VDD VDD VSS VSS gf180mcu_fd_sc_mcu7t5v0__fillcap_8
XFILLER_110_872 VDD VDD VSS VSS gf180mcu_fd_sc_mcu7t5v0__fill_2
XFILLER_83_734 VDD VDD VSS VSS gf180mcu_fd_sc_mcu7t5v0__fillcap_4
XFILLER_27_116 VDD VDD VSS VSS gf180mcu_fd_sc_mcu7t5v0__fillcap_16
XFILLER_68_797 VDD VDD VSS VSS gf180mcu_fd_sc_mcu7t5v0__fillcap_8
XFILLER_83_767 VDD VDD VSS VSS gf180mcu_fd_sc_mcu7t5v0__fill_2
XFILLER_82_244 VDD VDD VSS VSS gf180mcu_fd_sc_mcu7t5v0__fill_1
XFILLER_36_661 VDD VDD VSS VSS gf180mcu_fd_sc_mcu7t5v0__fillcap_4
X_2008_ _1843_/Z _2008_/A2 _2008_/A3 _1931_/Z _2008_/Z VDD VDD VSS VSS gf180mcu_fd_sc_mcu7t5v0__and4_4
XFILLER_35_171 VDD VDD VSS VSS gf180mcu_fd_sc_mcu7t5v0__fillcap_16
XFILLER_36_683 VDD VDD VSS VSS gf180mcu_fd_sc_mcu7t5v0__fill_2
XFILLER_23_388 VDD VDD VSS VSS gf180mcu_fd_sc_mcu7t5v0__fill_2
X_3959_ _3959_/D _2279_/I _3968_/CLK _3959_/Q VDD VDD VSS VSS gf180mcu_fd_sc_mcu7t5v0__dffrnq_1
XTAP_TAPCELL_ROW_21_556 VDD VSS gf180mcu_fd_sc_mcu7t5v0__filltie
XFILLER_125_909 VDD VDD VSS VSS gf180mcu_fd_sc_mcu7t5v0__fill_1
XFILLER_3_738 VDD VDD VSS VSS gf180mcu_fd_sc_mcu7t5v0__fill_1
XFILLER_132_452 VDD VDD VSS VSS gf180mcu_fd_sc_mcu7t5v0__fill_2
XFILLER_105_699 VDD VDD VSS VSS gf180mcu_fd_sc_mcu7t5v0__fill_1
XFILLER_101_850 VDD VDD VSS VSS gf180mcu_fd_sc_mcu7t5v0__fillcap_4
XFILLER_100_360 VDD VDD VSS VSS gf180mcu_fd_sc_mcu7t5v0__fillcap_16
XFILLER_58_263 VDD VDD VSS VSS gf180mcu_fd_sc_mcu7t5v0__fillcap_4
Xplace56 place56/I _2521_/S VDD VDD VSS VSS gf180mcu_fd_sc_mcu7t5v0__buf_8
XFILLER_73_244 VDD VDD VSS VSS gf180mcu_fd_sc_mcu7t5v0__fillcap_16
Xplace45 place45/I _2746_/S VDD VDD VSS VSS gf180mcu_fd_sc_mcu7t5v0__buf_8
Xplace78 _4092_/Q place78/Z VDD VDD VSS VSS gf180mcu_fd_sc_mcu7t5v0__buf_8
Xplace67 place67/I place67/Z VDD VDD VSS VSS gf180mcu_fd_sc_mcu7t5v0__buf_8
XTAP_TAPCELL_ROW_29_667 VDD VSS gf180mcu_fd_sc_mcu7t5v0__filltie
Xplace89 _4022_/Q place89/Z VDD VDD VSS VSS gf180mcu_fd_sc_mcu7t5v0__buf_8
XFILLER_54_491 VDD VDD VSS VSS gf180mcu_fd_sc_mcu7t5v0__fill_2
XTAP_TAPCELL_ROW_64_1112 VDD VSS gf180mcu_fd_sc_mcu7t5v0__filltie
XTAP_TAPCELL_ROW_64_1123 VDD VSS gf180mcu_fd_sc_mcu7t5v0__filltie
XFILLER_92_89 VDD VDD VSS VSS gf180mcu_fd_sc_mcu7t5v0__fillcap_16
XFILLER_25_72 VDD VDD VSS VSS gf180mcu_fd_sc_mcu7t5v0__fillcap_16
XFILLER_42_664 VDD VDD VSS VSS gf180mcu_fd_sc_mcu7t5v0__fill_1
XTAP_TAPCELL_ROW_40_810 VDD VSS gf180mcu_fd_sc_mcu7t5v0__filltie
XTAP_TAPCELL_ROW_75_1263 VDD VSS gf180mcu_fd_sc_mcu7t5v0__filltie
XFILLER_96_314 VDD VDD VSS VSS gf180mcu_fd_sc_mcu7t5v0__fill_1
XFILLER_37_6 VDD VDD VSS VSS gf180mcu_fd_sc_mcu7t5v0__fill_1
X_2290_ _3632_/Q place81/Z _2298_/S _3632_/D VDD VDD VSS VSS gf180mcu_fd_sc_mcu7t5v0__mux2_2
XFILLER_77_572 VDD VDD VSS VSS gf180mcu_fd_sc_mcu7t5v0__fill_1
XFILLER_2_65 VDD VDD VSS VSS gf180mcu_fd_sc_mcu7t5v0__fill_2
XTAP_TAPCELL_ROW_48_910 VDD VSS gf180mcu_fd_sc_mcu7t5v0__filltie
XTAP_TAPCELL_ROW_127_1938 VDD VSS gf180mcu_fd_sc_mcu7t5v0__filltie
XFILLER_92_575 VDD VDD VSS VSS gf180mcu_fd_sc_mcu7t5v0__fillcap_4
XFILLER_18_661 VDD VDD VSS VSS gf180mcu_fd_sc_mcu7t5v0__fillcap_4
XFILLER_64_244 VDD VDD VSS VSS gf180mcu_fd_sc_mcu7t5v0__fill_1
XFILLER_92_597 VDD VDD VSS VSS gf180mcu_fd_sc_mcu7t5v0__fillcap_8
XFILLER_80_737 VDD VDD VSS VSS gf180mcu_fd_sc_mcu7t5v0__fillcap_64
XFILLER_18_683 VDD VDD VSS VSS gf180mcu_fd_sc_mcu7t5v0__fillcap_4
XFILLER_60_450 VDD VDD VSS VSS gf180mcu_fd_sc_mcu7t5v0__fillcap_4
X_3813_ _3813_/D _4153_/CLK _3813_/Q VDD VDD VSS VSS gf180mcu_fd_sc_mcu7t5v0__dffq_1
XFILLER_32_174 VDD VDD VSS VSS gf180mcu_fd_sc_mcu7t5v0__fill_1
X_3744_ _3744_/D _4094_/CLK _3744_/Q VDD VDD VSS VSS gf180mcu_fd_sc_mcu7t5v0__dffq_1
X_3675_ _3675_/D _4166_/CLK _3675_/Q VDD VDD VSS VSS gf180mcu_fd_sc_mcu7t5v0__dffq_1
X_2626_ place89/Z _3774_/Q _2638_/S _3774_/D VDD VDD VSS VSS gf180mcu_fd_sc_mcu7t5v0__mux2_2
Xoutput166 _2267_/ZN s_axi_rdata[27] VDD VDD VSS VSS gf180mcu_fd_sc_mcu7t5v0__dlyb_1
Xoutput155 _2247_/ZN s_axi_rdata[17] VDD VDD VSS VSS gf180mcu_fd_sc_mcu7t5v0__dlyb_1
Xoutput177 _2223_/ZN s_axi_rdata[8] VDD VDD VSS VSS gf180mcu_fd_sc_mcu7t5v0__dlyb_1
Xoutput144 _4128_/Q s_axi_arready VDD VDD VSS VSS gf180mcu_fd_sc_mcu7t5v0__dlyb_1
XFILLER_88_804 VDD VDD VSS VSS gf180mcu_fd_sc_mcu7t5v0__fill_1
XFILLER_87_314 VDD VDD VSS VSS gf180mcu_fd_sc_mcu7t5v0__fillcap_16
XFILLER_68_583 VDD VDD VSS VSS gf180mcu_fd_sc_mcu7t5v0__fillcap_8
X_4158_ _4159_/Q input92/Z _4163_/CLK _4158_/Q VDD VDD VSS VSS gf180mcu_fd_sc_mcu7t5v0__dffsnq_1
XFILLER_46_27 VDD VDD VSS VSS gf180mcu_fd_sc_mcu7t5v0__fillcap_8
XFILLER_56_745 VDD VDD VSS VSS gf180mcu_fd_sc_mcu7t5v0__fill_1
X_4089_ _4089_/D _2279_/I _4092_/CLK _4089_/Q VDD VDD VSS VSS gf180mcu_fd_sc_mcu7t5v0__dffrnq_1
XFILLER_15_119 VDD VDD VSS VSS gf180mcu_fd_sc_mcu7t5v0__fillcap_16
XTAP_TAPCELL_ROW_26_626 VDD VSS gf180mcu_fd_sc_mcu7t5v0__filltie
XFILLER_24_664 VDD VDD VSS VSS gf180mcu_fd_sc_mcu7t5v0__fill_1
XFILLER_62_37 VDD VDD VSS VSS gf180mcu_fd_sc_mcu7t5v0__fillcap_32
XFILLER_70_247 VDD VDD VSS VSS gf180mcu_fd_sc_mcu7t5v0__fillcap_64
XFILLER_12_815 VDD VDD VSS VSS gf180mcu_fd_sc_mcu7t5v0__fillcap_4
XFILLER_7_318 VDD VDD VSS VSS gf180mcu_fd_sc_mcu7t5v0__fillcap_32
XFILLER_109_246 VDD VDD VSS VSS gf180mcu_fd_sc_mcu7t5v0__fillcap_16
XFILLER_124_216 VDD VDD VSS VSS gf180mcu_fd_sc_mcu7t5v0__fillcap_16
XFILLER_109_279 VDD VDD VSS VSS gf180mcu_fd_sc_mcu7t5v0__fill_1
XFILLER_106_931 VDD VDD VSS VSS gf180mcu_fd_sc_mcu7t5v0__fill_2
XFILLER_121_912 VDD VDD VSS VSS gf180mcu_fd_sc_mcu7t5v0__fillcap_16
XFILLER_117_290 VDD VDD VSS VSS gf180mcu_fd_sc_mcu7t5v0__fillcap_4
XTAP_TAPCELL_ROW_111_1728 VDD VSS gf180mcu_fd_sc_mcu7t5v0__filltie
XFILLER_78_314 VDD VDD VSS VSS gf180mcu_fd_sc_mcu7t5v0__fill_1
XFILLER_120_444 VDD VDD VSS VSS gf180mcu_fd_sc_mcu7t5v0__fill_1
XFILLER_94_807 VDD VDD VSS VSS gf180mcu_fd_sc_mcu7t5v0__fillcap_64
XTAP_TAPCELL_ROW_6_362 VDD VSS gf180mcu_fd_sc_mcu7t5v0__filltie
XTAP_TAPCELL_ROW_70_1193 VDD VSS gf180mcu_fd_sc_mcu7t5v0__filltie
XFILLER_35_907 VDD VDD VSS VSS gf180mcu_fd_sc_mcu7t5v0__fill_2
XFILLER_74_597 VDD VDD VSS VSS gf180mcu_fd_sc_mcu7t5v0__fillcap_16
XFILLER_62_737 VDD VDD VSS VSS gf180mcu_fd_sc_mcu7t5v0__fillcap_64
XFILLER_36_93 VDD VDD VSS VSS gf180mcu_fd_sc_mcu7t5v0__fillcap_8
XTAP_TAPCELL_ROW_122_1868 VDD VSS gf180mcu_fd_sc_mcu7t5v0__filltie
XFILLER_30_667 VDD VDD VSS VSS gf180mcu_fd_sc_mcu7t5v0__fillcap_16
XFILLER_128_577 VDD VDD VSS VSS gf180mcu_fd_sc_mcu7t5v0__fill_2
XFILLER_115_216 VDD VDD VSS VSS gf180mcu_fd_sc_mcu7t5v0__fill_1
XFILLER_6_395 VDD VDD VSS VSS gf180mcu_fd_sc_mcu7t5v0__fillcap_4
X_3460_ _4148_/Q _2182_/Z _3476_/B _3462_/A2 VDD VDD VSS VSS gf180mcu_fd_sc_mcu7t5v0__aoi21_1
X_3391_ _3391_/A1 _3394_/A4 _3391_/B _4089_/Q _3392_/B VDD VDD VSS VSS gf180mcu_fd_sc_mcu7t5v0__oai211_1
XFILLER_111_422 VDD VDD VSS VSS gf180mcu_fd_sc_mcu7t5v0__fillcap_16
XFILLER_96_100 VDD VDD VSS VSS gf180mcu_fd_sc_mcu7t5v0__fillcap_4
XFILLER_123_282 VDD VDD VSS VSS gf180mcu_fd_sc_mcu7t5v0__fillcap_64
XFILLER_28_2 VDD VDD VSS VSS gf180mcu_fd_sc_mcu7t5v0__fillcap_16
X_2273_ _2273_/I _2273_/ZN VDD VDD VSS VSS gf180mcu_fd_sc_mcu7t5v0__inv_1
X_4012_ _4012_/D input92/Z _4146_/CLK _4012_/Q VDD VDD VSS VSS gf180mcu_fd_sc_mcu7t5v0__dffrnq_1
XFILLER_111_477 VDD VDD VSS VSS gf180mcu_fd_sc_mcu7t5v0__fillcap_8
XFILLER_97_689 VDD VDD VSS VSS gf180mcu_fd_sc_mcu7t5v0__fillcap_8
XFILLER_96_177 VDD VDD VSS VSS gf180mcu_fd_sc_mcu7t5v0__fillcap_32
XFILLER_84_328 VDD VDD VSS VSS gf180mcu_fd_sc_mcu7t5v0__fillcap_32
XFILLER_84_317 VDD VDD VSS VSS gf180mcu_fd_sc_mcu7t5v0__fillcap_4
XFILLER_78_870 VDD VDD VSS VSS gf180mcu_fd_sc_mcu7t5v0__fillcap_4
XFILLER_38_723 VDD VDD VSS VSS gf180mcu_fd_sc_mcu7t5v0__fillcap_8
XTAP_TAPCELL_ROW_88_1432 VDD VSS gf180mcu_fd_sc_mcu7t5v0__filltie
XFILLER_92_372 VDD VDD VSS VSS gf180mcu_fd_sc_mcu7t5v0__fillcap_8
XFILLER_80_523 VDD VDD VSS VSS gf180mcu_fd_sc_mcu7t5v0__fill_2
XFILLER_52_225 VDD VDD VSS VSS gf180mcu_fd_sc_mcu7t5v0__fillcap_16
XFILLER_80_545 VDD VDD VSS VSS gf180mcu_fd_sc_mcu7t5v0__fillcap_32
XFILLER_52_247 VDD VDD VSS VSS gf180mcu_fd_sc_mcu7t5v0__fillcap_32
XTAP_TAPCELL_ROW_51_949 VDD VSS gf180mcu_fd_sc_mcu7t5v0__filltie
X_1988_ _3391_/B _3968_/Q _3967_/Q _3389_/A1 _1988_/C _1993_/A2 VDD VDD VSS VSS gf180mcu_fd_sc_mcu7t5v0__aoi221_1
XTAP_TAPCELL_ROW_99_1572 VDD VSS gf180mcu_fd_sc_mcu7t5v0__filltie
XFILLER_20_177 VDD VDD VSS VSS gf180mcu_fd_sc_mcu7t5v0__fillcap_16
XTAP_TAPCELL_ROW_31_684 VDD VSS gf180mcu_fd_sc_mcu7t5v0__filltie
XTAP_TAPCELL_ROW_31_695 VDD VSS gf180mcu_fd_sc_mcu7t5v0__filltie
X_3727_ _3727_/D _3755_/CLK _3727_/Q VDD VDD VSS VSS gf180mcu_fd_sc_mcu7t5v0__dffq_1
XFILLER_106_238 VDD VDD VSS VSS gf180mcu_fd_sc_mcu7t5v0__fillcap_4
X_3658_ _3658_/D _3749_/CLK _3658_/Q VDD VDD VSS VSS gf180mcu_fd_sc_mcu7t5v0__dffq_1
X_3589_ _3843_/Q _3851_/Q _3859_/Q _3867_/Q place76/Z place75/Z _3589_/Z VDD VDD VSS
+ VSS gf180mcu_fd_sc_mcu7t5v0__mux4_1
X_2609_ place88/Z _3767_/Q _2619_/S _3767_/D VDD VDD VSS VSS gf180mcu_fd_sc_mcu7t5v0__mux2_2
XFILLER_115_772 VDD VDD VSS VSS gf180mcu_fd_sc_mcu7t5v0__fillcap_64
XFILLER_103_912 VDD VDD VSS VSS gf180mcu_fd_sc_mcu7t5v0__fillcap_16
XFILLER_88_667 VDD VDD VSS VSS gf180mcu_fd_sc_mcu7t5v0__fillcap_64
XFILLER_76_807 VDD VDD VSS VSS gf180mcu_fd_sc_mcu7t5v0__fillcap_32
XFILLER_75_328 VDD VDD VSS VSS gf180mcu_fd_sc_mcu7t5v0__fillcap_8
XTAP_TAPCELL_ROW_3_321 VDD VSS gf180mcu_fd_sc_mcu7t5v0__filltie
XFILLER_68_391 VDD VDD VSS VSS gf180mcu_fd_sc_mcu7t5v0__fillcap_8
XFILLER_113_43 VDD VDD VSS VSS gf180mcu_fd_sc_mcu7t5v0__fillcap_4
XFILLER_84_873 VDD VDD VSS VSS gf180mcu_fd_sc_mcu7t5v0__fill_2
XTAP_TAPCELL_ROW_39_795 VDD VSS gf180mcu_fd_sc_mcu7t5v0__filltie
XFILLER_56_597 VDD VDD VSS VSS gf180mcu_fd_sc_mcu7t5v0__fillcap_64
XTAP_TAPCELL_ROW_108_1690 VDD VSS gf180mcu_fd_sc_mcu7t5v0__filltie
XFILLER_40_932 VDD VDD VSS VSS gf180mcu_fd_sc_mcu7t5v0__fill_2
XFILLER_52_792 VDD VDD VSS VSS gf180mcu_fd_sc_mcu7t5v0__fillcap_8
XFILLER_12_667 VDD VDD VSS VSS gf180mcu_fd_sc_mcu7t5v0__fillcap_16
XTAP_TAPCELL_ROW_59_1055 VDD VSS gf180mcu_fd_sc_mcu7t5v0__filltie
XFILLER_4_877 VDD VDD VSS VSS gf180mcu_fd_sc_mcu7t5v0__fillcap_32
XFILLER_105_260 VDD VDD VSS VSS gf180mcu_fd_sc_mcu7t5v0__fillcap_8
XTAP_TAPCELL_ROW_72_1222 VDD VSS gf180mcu_fd_sc_mcu7t5v0__filltie
XFILLER_121_731 VDD VDD VSS VSS gf180mcu_fd_sc_mcu7t5v0__fillcap_4
XFILLER_120_263 VDD VDD VSS VSS gf180mcu_fd_sc_mcu7t5v0__fillcap_8
XFILLER_78_177 VDD VDD VSS VSS gf180mcu_fd_sc_mcu7t5v0__fillcap_32
XFILLER_66_317 VDD VDD VSS VSS gf180mcu_fd_sc_mcu7t5v0__fillcap_64
XFILLER_93_136 VDD VDD VSS VSS gf180mcu_fd_sc_mcu7t5v0__fillcap_4
XFILLER_19_244 VDD VDD VSS VSS gf180mcu_fd_sc_mcu7t5v0__fill_1
X_2960_ _4046_/Q _3926_/Q _2972_/S _3926_/D VDD VDD VSS VSS gf180mcu_fd_sc_mcu7t5v0__mux2_2
XTAP_TAPCELL_ROW_83_1362 VDD VSS gf180mcu_fd_sc_mcu7t5v0__filltie
XFILLER_22_409 VDD VDD VSS VSS gf180mcu_fd_sc_mcu7t5v0__fillcap_16
X_2891_ _2891_/A1 _2900_/S _2891_/B _3893_/D VDD VDD VSS VSS gf180mcu_fd_sc_mcu7t5v0__oai21_1
X_1911_ _1853_/B _4139_/Q _1913_/B2 VDD VDD VSS VSS gf180mcu_fd_sc_mcu7t5v0__nand2_1
XFILLER_31_932 VDD VDD VSS VSS gf180mcu_fd_sc_mcu7t5v0__fill_2
X_1842_ _1836_/Z _1837_/Z _1842_/A3 _1842_/B _1949_/A2 VDD VDD VSS VSS gf180mcu_fd_sc_mcu7t5v0__oai31_2
XFILLER_30_453 VDD VDD VSS VSS gf180mcu_fd_sc_mcu7t5v0__fill_2
XFILLER_129_842 VDD VDD VSS VSS gf180mcu_fd_sc_mcu7t5v0__fill_2
XFILLER_8_97 VDD VDD VSS VSS gf180mcu_fd_sc_mcu7t5v0__fillcap_8
X_3512_ _4110_/Q _4111_/Q _4112_/Q _3516_/A3 VDD VDD VSS VSS gf180mcu_fd_sc_mcu7t5v0__nand3_1
X_3443_ _4100_/Q _4099_/Q _3443_/B _3444_/A2 VDD VDD VSS VSS gf180mcu_fd_sc_mcu7t5v0__aoi21_1
XFILLER_124_591 VDD VDD VSS VSS gf180mcu_fd_sc_mcu7t5v0__fillcap_4
XFILLER_58_807 VDD VDD VSS VSS gf180mcu_fd_sc_mcu7t5v0__fillcap_16
XFILLER_112_786 VDD VDD VSS VSS gf180mcu_fd_sc_mcu7t5v0__fillcap_16
XFILLER_97_475 VDD VDD VSS VSS gf180mcu_fd_sc_mcu7t5v0__fillcap_8
X_2256_ _3955_/Q place63/Z place67/Z _3980_/Q _3923_/Q place72/Z _2257_/I VDD VDD
+ VSS VSS gf180mcu_fd_sc_mcu7t5v0__aoi222_1
XFILLER_85_648 VDD VDD VSS VSS gf180mcu_fd_sc_mcu7t5v0__fillcap_4
XFILLER_27_18 VDD VDD VSS VSS gf180mcu_fd_sc_mcu7t5v0__fill_2
X_2187_ _2187_/A1 _2187_/A2 _2187_/A3 _2187_/ZN VDD VDD VSS VSS gf180mcu_fd_sc_mcu7t5v0__nand3_2
XFILLER_26_737 VDD VDD VSS VSS gf180mcu_fd_sc_mcu7t5v0__fillcap_64
XFILLER_38_597 VDD VDD VSS VSS gf180mcu_fd_sc_mcu7t5v0__fillcap_64
XTAP_TAPCELL_ROW_36_754 VDD VSS gf180mcu_fd_sc_mcu7t5v0__filltie
XFILLER_53_578 VDD VDD VSS VSS gf180mcu_fd_sc_mcu7t5v0__fillcap_4
XFILLER_40_239 VDD VDD VSS VSS gf180mcu_fd_sc_mcu7t5v0__fillcap_4
XFILLER_43_39 VDD VDD VSS VSS gf180mcu_fd_sc_mcu7t5v0__fillcap_16
XFILLER_119_385 VDD VDD VSS VSS gf180mcu_fd_sc_mcu7t5v0__fillcap_8
XFILLER_4_107 VDD VDD VSS VSS gf180mcu_fd_sc_mcu7t5v0__fillcap_32
XFILLER_89_932 VDD VDD VSS VSS gf180mcu_fd_sc_mcu7t5v0__fill_2
XFILLER_130_561 VDD VDD VSS VSS gf180mcu_fd_sc_mcu7t5v0__fill_2
XFILLER_130_550 VDD VDD VSS VSS gf180mcu_fd_sc_mcu7t5v0__fill_1
XFILLER_48_317 VDD VDD VSS VSS gf180mcu_fd_sc_mcu7t5v0__fillcap_64
XFILLER_29_531 VDD VDD VSS VSS gf180mcu_fd_sc_mcu7t5v0__fill_1
XFILLER_75_158 VDD VDD VSS VSS gf180mcu_fd_sc_mcu7t5v0__fillcap_8
XFILLER_57_862 VDD VDD VSS VSS gf180mcu_fd_sc_mcu7t5v0__fill_2
XFILLER_91_629 VDD VDD VSS VSS gf180mcu_fd_sc_mcu7t5v0__fill_1
XFILLER_44_512 VDD VDD VSS VSS gf180mcu_fd_sc_mcu7t5v0__fillcap_8
XFILLER_56_383 VDD VDD VSS VSS gf180mcu_fd_sc_mcu7t5v0__fill_2
XFILLER_16_247 VDD VDD VSS VSS gf180mcu_fd_sc_mcu7t5v0__fillcap_64
XFILLER_16_236 VDD VDD VSS VSS gf180mcu_fd_sc_mcu7t5v0__fillcap_8
XFILLER_31_206 VDD VDD VSS VSS gf180mcu_fd_sc_mcu7t5v0__fillcap_4
XFILLER_129_116 VDD VDD VSS VSS gf180mcu_fd_sc_mcu7t5v0__fillcap_16
XFILLER_33_94 VDD VDD VSS VSS gf180mcu_fd_sc_mcu7t5v0__fill_1
XFILLER_33_72 VDD VDD VSS VSS gf180mcu_fd_sc_mcu7t5v0__fillcap_16
XFILLER_8_457 VDD VDD VSS VSS gf180mcu_fd_sc_mcu7t5v0__fillcap_64
XPHY_EDGE_ROW_49_Left_182 VDD VSS gf180mcu_fd_sc_mcu7t5v0__endcap
XFILLER_4_663 VDD VDD VSS VSS gf180mcu_fd_sc_mcu7t5v0__fill_2
XFILLER_79_442 VDD VDD VSS VSS gf180mcu_fd_sc_mcu7t5v0__fill_2
XTAP_TAPCELL_ROW_130_1978 VDD VSS gf180mcu_fd_sc_mcu7t5v0__filltie
X_2110_ input97/Z _2110_/A2 _2181_/A3 VDD VDD VSS VSS gf180mcu_fd_sc_mcu7t5v0__nand2_1
X_3090_ _3986_/Q _3090_/I1 _4131_/D _3986_/D VDD VDD VSS VSS gf180mcu_fd_sc_mcu7t5v0__mux2_2
XPHY_EDGE_ROW_58_Left_191 VDD VSS gf180mcu_fd_sc_mcu7t5v0__endcap
X_2041_ _2041_/A1 _2079_/A2 _2051_/A3 VDD VDD VSS VSS gf180mcu_fd_sc_mcu7t5v0__nor2_1
XFILLER_90_651 VDD VDD VSS VSS gf180mcu_fd_sc_mcu7t5v0__fill_1
XFILLER_81_139 VDD VDD VSS VSS gf180mcu_fd_sc_mcu7t5v0__fill_1
XFILLER_62_364 VDD VDD VSS VSS gf180mcu_fd_sc_mcu7t5v0__fillcap_16
X_3992_ _3992_/D input92/Z _4028_/CLK _3992_/Q VDD VDD VSS VSS gf180mcu_fd_sc_mcu7t5v0__dffrnq_1
X_2943_ _4038_/Q _3918_/Q _2972_/S _3918_/D VDD VDD VSS VSS gf180mcu_fd_sc_mcu7t5v0__mux2_2
XFILLER_95_2 VDD VDD VSS VSS gf180mcu_fd_sc_mcu7t5v0__fillcap_4
XTAP_TAPCELL_ROW_33_713 VDD VSS gf180mcu_fd_sc_mcu7t5v0__filltie
XFILLER_50_559 VDD VDD VSS VSS gf180mcu_fd_sc_mcu7t5v0__fillcap_16
X_2874_ place90/Z _2900_/S _2875_/B VDD VDD VSS VSS gf180mcu_fd_sc_mcu7t5v0__nand2_1
XFILLER_31_784 VDD VDD VSS VSS gf180mcu_fd_sc_mcu7t5v0__fill_1
X_1825_ _3897_/Q _2899_/A1 VDD VDD VSS VSS gf180mcu_fd_sc_mcu7t5v0__clkinv_1
XFILLER_116_311 VDD VDD VSS VSS gf180mcu_fd_sc_mcu7t5v0__fillcap_4
XTAP_TAPCELL_ROW_96_1531 VDD VSS gf180mcu_fd_sc_mcu7t5v0__filltie
XFILLER_128_193 VDD VDD VSS VSS gf180mcu_fd_sc_mcu7t5v0__fill_2
X_3426_ _4102_/Q _4103_/Q _3477_/A2 VDD VDD VSS VSS gf180mcu_fd_sc_mcu7t5v0__nor2_1
X_3357_ _3370_/A1 _3316_/Z _3357_/Z VDD VDD VSS VSS gf180mcu_fd_sc_mcu7t5v0__or2_1
XFILLER_97_272 VDD VDD VSS VSS gf180mcu_fd_sc_mcu7t5v0__fill_1
X_3288_ _3627_/I1 _3288_/A2 _3288_/Z VDD VDD VSS VSS gf180mcu_fd_sc_mcu7t5v0__xor2_1
X_2239_ _2239_/I _2239_/ZN VDD VDD VSS VSS gf180mcu_fd_sc_mcu7t5v0__inv_1
XFILLER_73_629 VDD VDD VSS VSS gf180mcu_fd_sc_mcu7t5v0__fill_1
XFILLER_72_139 VDD VDD VSS VSS gf180mcu_fd_sc_mcu7t5v0__fillcap_4
XFILLER_53_364 VDD VDD VSS VSS gf180mcu_fd_sc_mcu7t5v0__fillcap_32
XTAP_TAPCELL_ROW_11_429 VDD VSS gf180mcu_fd_sc_mcu7t5v0__filltie
XFILLER_21_272 VDD VDD VSS VSS gf180mcu_fd_sc_mcu7t5v0__fillcap_8
XFILLER_22_795 VDD VDD VSS VSS gf180mcu_fd_sc_mcu7t5v0__fillcap_8
XFILLER_70_37 VDD VDD VSS VSS gf180mcu_fd_sc_mcu7t5v0__fillcap_8
XFILLER_119_53 VDD VDD VSS VSS gf180mcu_fd_sc_mcu7t5v0__fillcap_16
XFILLER_108_823 VDD VDD VSS VSS gf180mcu_fd_sc_mcu7t5v0__fillcap_8
XTAP_TAPCELL_ROW_56_1014 VDD VSS gf180mcu_fd_sc_mcu7t5v0__filltie
XFILLER_122_347 VDD VDD VSS VSS gf180mcu_fd_sc_mcu7t5v0__fill_2
XFILLER_122_369 VDD VDD VSS VSS gf180mcu_fd_sc_mcu7t5v0__fill_1
XFILLER_95_209 VDD VDD VSS VSS gf180mcu_fd_sc_mcu7t5v0__fill_1
XFILLER_95_67 VDD VDD VSS VSS gf180mcu_fd_sc_mcu7t5v0__fill_2
XFILLER_76_445 VDD VDD VSS VSS gf180mcu_fd_sc_mcu7t5v0__fillcap_8
XTAP_TAPCELL_ROW_19_529 VDD VSS gf180mcu_fd_sc_mcu7t5v0__filltie
XFILLER_17_556 VDD VDD VSS VSS gf180mcu_fd_sc_mcu7t5v0__fillcap_4
XFILLER_29_383 VDD VDD VSS VSS gf180mcu_fd_sc_mcu7t5v0__fillcap_8
XFILLER_60_813 VDD VDD VSS VSS gf180mcu_fd_sc_mcu7t5v0__fill_1
XTAP_TAPCELL_ROW_67_1154 VDD VSS gf180mcu_fd_sc_mcu7t5v0__filltie
XFILLER_71_150 VDD VDD VSS VSS gf180mcu_fd_sc_mcu7t5v0__fillcap_4
XTAP_TAPCELL_ROW_80_1321 VDD VSS gf180mcu_fd_sc_mcu7t5v0__filltie
XFILLER_71_172 VDD VDD VSS VSS gf180mcu_fd_sc_mcu7t5v0__fillcap_16
XFILLER_71_194 VDD VDD VSS VSS gf180mcu_fd_sc_mcu7t5v0__fill_1
XTAP_TAPCELL_ROW_80_1332 VDD VSS gf180mcu_fd_sc_mcu7t5v0__filltie
XFILLER_44_82 VDD VDD VSS VSS gf180mcu_fd_sc_mcu7t5v0__fillcap_16
XTAP_TAPCELL_ROW_119_1829 VDD VSS gf180mcu_fd_sc_mcu7t5v0__filltie
XFILLER_8_276 VDD VDD VSS VSS gf180mcu_fd_sc_mcu7t5v0__fillcap_32
X_2590_ _3760_/Q place87/Z _2598_/S _3760_/D VDD VDD VSS VSS gf180mcu_fd_sc_mcu7t5v0__mux2_2
XTAP_TAPCELL_ROW_78_1294 VDD VSS gf180mcu_fd_sc_mcu7t5v0__filltie
X_3211_ _4044_/Q _4012_/Q _4129_/D _4044_/D VDD VDD VSS VSS gf180mcu_fd_sc_mcu7t5v0__mux2_2
XTAP_TAPCELL_ROW_91_1472 VDD VSS gf180mcu_fd_sc_mcu7t5v0__filltie
XFILLER_68_924 VDD VDD VSS VSS gf180mcu_fd_sc_mcu7t5v0__fillcap_8
XFILLER_122_881 VDD VDD VSS VSS gf180mcu_fd_sc_mcu7t5v0__fill_2
X_3142_ _4011_/Q _3142_/I1 _3160_/S _4011_/D VDD VDD VSS VSS gf180mcu_fd_sc_mcu7t5v0__mux2_2
XFILLER_55_607 VDD VDD VSS VSS gf180mcu_fd_sc_mcu7t5v0__fillcap_16
X_3073_ _4040_/Q _3977_/Q _3081_/S _3977_/D VDD VDD VSS VSS gf180mcu_fd_sc_mcu7t5v0__mux2_2
XFILLER_55_629 VDD VDD VSS VSS gf180mcu_fd_sc_mcu7t5v0__fill_1
Xaz_v_uart_top_187 s_axi_rresp[1] VDD VDD VSS VSS gf180mcu_fd_sc_mcu7t5v0__tiel
X_2024_ _4134_/Q _2024_/A2 _2024_/Z VDD VDD VSS VSS gf180mcu_fd_sc_mcu7t5v0__xor2_1
XTAP_TAPCELL_ROW_46_882 VDD VSS gf180mcu_fd_sc_mcu7t5v0__filltie
XFILLER_63_695 VDD VDD VSS VSS gf180mcu_fd_sc_mcu7t5v0__fillcap_4
X_3975_ _3975_/D _2279_/I _3975_/CLK _3975_/Q VDD VDD VSS VSS gf180mcu_fd_sc_mcu7t5v0__dffrnq_1
X_2926_ _4030_/Q _3910_/Q _2972_/S _3910_/D VDD VDD VSS VSS gf180mcu_fd_sc_mcu7t5v0__mux2_2
XFILLER_31_570 VDD VDD VSS VSS gf180mcu_fd_sc_mcu7t5v0__fillcap_32
X_2857_ place88/Z _3879_/Q _2867_/S _3879_/D VDD VDD VSS VSS gf180mcu_fd_sc_mcu7t5v0__mux2_2
X_1808_ _3900_/Q _2905_/A1 VDD VDD VSS VSS gf180mcu_fd_sc_mcu7t5v0__clkinv_1
XTAP_TAPCELL_ROW_100_1590 VDD VSS gf180mcu_fd_sc_mcu7t5v0__filltie
Xhold210 uart_rx_pin hold210/Z VDD VDD VSS VSS gf180mcu_fd_sc_mcu7t5v0__dlyc_1
XFILLER_117_664 VDD VDD VSS VSS gf180mcu_fd_sc_mcu7t5v0__fillcap_8
XFILLER_104_314 VDD VDD VSS VSS gf180mcu_fd_sc_mcu7t5v0__fill_1
Xhold221 s_axi_wdata[18] hold221/Z VDD VDD VSS VSS gf180mcu_fd_sc_mcu7t5v0__dlyc_1
XFILLER_131_111 VDD VDD VSS VSS gf180mcu_fd_sc_mcu7t5v0__fillcap_16
XFILLER_120_807 VDD VDD VSS VSS gf180mcu_fd_sc_mcu7t5v0__fillcap_64
X_3409_ _4096_/Q _3409_/A2 _4096_/D VDD VDD VSS VSS gf180mcu_fd_sc_mcu7t5v0__xnor2_1
XFILLER_49_38 VDD VDD VSS VSS gf180mcu_fd_sc_mcu7t5v0__fill_2
XFILLER_49_49 VDD VDD VSS VSS gf180mcu_fd_sc_mcu7t5v0__fillcap_16
XFILLER_105_44 VDD VDD VSS VSS gf180mcu_fd_sc_mcu7t5v0__fillcap_8
XFILLER_100_542 VDD VDD VSS VSS gf180mcu_fd_sc_mcu7t5v0__fillcap_32
XFILLER_85_220 VDD VDD VSS VSS gf180mcu_fd_sc_mcu7t5v0__fillcap_4
XFILLER_100_586 VDD VDD VSS VSS gf180mcu_fd_sc_mcu7t5v0__fillcap_8
XFILLER_46_629 VDD VDD VSS VSS gf180mcu_fd_sc_mcu7t5v0__fillcap_8
XFILLER_58_478 VDD VDD VSS VSS gf180mcu_fd_sc_mcu7t5v0__fillcap_4
XFILLER_121_10 VDD VDD VSS VSS gf180mcu_fd_sc_mcu7t5v0__fillcap_4
XFILLER_100_597 VDD VDD VSS VSS gf180mcu_fd_sc_mcu7t5v0__fillcap_4
XFILLER_27_854 VDD VDD VSS VSS gf180mcu_fd_sc_mcu7t5v0__fill_2
XFILLER_26_364 VDD VDD VSS VSS gf180mcu_fd_sc_mcu7t5v0__fillcap_4
XFILLER_54_662 VDD VDD VSS VSS gf180mcu_fd_sc_mcu7t5v0__fill_2
XTAP_TAPCELL_ROW_103_1619 VDD VSS gf180mcu_fd_sc_mcu7t5v0__filltie
XFILLER_81_492 VDD VDD VSS VSS gf180mcu_fd_sc_mcu7t5v0__fillcap_64
XFILLER_128_929 VDD VDD VSS VSS gf180mcu_fd_sc_mcu7t5v0__fillcap_4
XTAP_TAPCELL_ROW_24_598 VDD VSS gf180mcu_fd_sc_mcu7t5v0__filltie
XTAP_TAPCELL_ROW_62_1095 VDD VSS gf180mcu_fd_sc_mcu7t5v0__filltie
XFILLER_123_656 VDD VDD VSS VSS gf180mcu_fd_sc_mcu7t5v0__fillcap_4
XFILLER_96_518 VDD VDD VSS VSS gf180mcu_fd_sc_mcu7t5v0__fillcap_4
XFILLER_122_177 VDD VDD VSS VSS gf180mcu_fd_sc_mcu7t5v0__fillcap_64
XFILLER_110_317 VDD VDD VSS VSS gf180mcu_fd_sc_mcu7t5v0__fillcap_64
XFILLER_77_776 VDD VDD VSS VSS gf180mcu_fd_sc_mcu7t5v0__fill_1
XFILLER_37_607 VDD VDD VSS VSS gf180mcu_fd_sc_mcu7t5v0__fillcap_4
XFILLER_39_82 VDD VDD VSS VSS gf180mcu_fd_sc_mcu7t5v0__fill_1
XFILLER_39_93 VDD VDD VSS VSS gf180mcu_fd_sc_mcu7t5v0__fill_1
XFILLER_37_629 VDD VDD VSS VSS gf180mcu_fd_sc_mcu7t5v0__fill_1
XFILLER_49_478 VDD VDD VSS VSS gf180mcu_fd_sc_mcu7t5v0__fillcap_8
XFILLER_91_212 VDD VDD VSS VSS gf180mcu_fd_sc_mcu7t5v0__fillcap_8
XFILLER_18_843 VDD VDD VSS VSS gf180mcu_fd_sc_mcu7t5v0__fill_1
XFILLER_91_278 VDD VDD VSS VSS gf180mcu_fd_sc_mcu7t5v0__fill_2
XFILLER_32_312 VDD VDD VSS VSS gf180mcu_fd_sc_mcu7t5v0__fill_2
XFILLER_60_621 VDD VDD VSS VSS gf180mcu_fd_sc_mcu7t5v0__fillcap_4
XTAP_TAPCELL_ROW_43_841 VDD VSS gf180mcu_fd_sc_mcu7t5v0__filltie
XFILLER_60_654 VDD VDD VSS VSS gf180mcu_fd_sc_mcu7t5v0__fillcap_8
XFILLER_13_570 VDD VDD VSS VSS gf180mcu_fd_sc_mcu7t5v0__fill_1
X_3760_ _3760_/D _3835_/CLK _3760_/Q VDD VDD VSS VSS gf180mcu_fd_sc_mcu7t5v0__dffq_1
XFILLER_20_518 VDD VDD VSS VSS gf180mcu_fd_sc_mcu7t5v0__fillcap_4
XFILLER_32_367 VDD VDD VSS VSS gf180mcu_fd_sc_mcu7t5v0__fillcap_16
X_3691_ _3691_/D _4072_/CLK _3691_/Q VDD VDD VSS VSS gf180mcu_fd_sc_mcu7t5v0__dffq_1
XTAP_TAPCELL_ROW_93_1501 VDD VSS gf180mcu_fd_sc_mcu7t5v0__filltie
X_2642_ _3540_/A1 _2642_/A2 _2695_/A2 VDD VDD VSS VSS gf180mcu_fd_sc_mcu7t5v0__nor2_4
XFILLER_114_667 VDD VDD VSS VSS gf180mcu_fd_sc_mcu7t5v0__fillcap_64
XFILLER_102_807 VDD VDD VSS VSS gf180mcu_fd_sc_mcu7t5v0__fillcap_16
XFILLER_59_209 VDD VDD VSS VSS gf180mcu_fd_sc_mcu7t5v0__fill_1
XFILLER_68_765 VDD VDD VSS VSS gf180mcu_fd_sc_mcu7t5v0__fill_2
X_3125_ _4003_/Q _3125_/I1 _3160_/S _4003_/D VDD VDD VSS VSS gf180mcu_fd_sc_mcu7t5v0__mux2_2
XFILLER_95_562 VDD VDD VSS VSS gf180mcu_fd_sc_mcu7t5v0__fillcap_64
XFILLER_83_702 VDD VDD VSS VSS gf180mcu_fd_sc_mcu7t5v0__fillcap_32
XFILLER_28_618 VDD VDD VSS VSS gf180mcu_fd_sc_mcu7t5v0__fillcap_4
X_3056_ _4050_/Q _3970_/Q _3081_/S _3970_/D VDD VDD VSS VSS gf180mcu_fd_sc_mcu7t5v0__mux2_2
XFILLER_71_908 VDD VDD VSS VSS gf180mcu_fd_sc_mcu7t5v0__fill_2
X_2007_ place87/Z _2007_/A2 _2007_/B _4127_/D VDD VDD VSS VSS gf180mcu_fd_sc_mcu7t5v0__aoi21_1
XFILLER_51_632 VDD VDD VSS VSS gf180mcu_fd_sc_mcu7t5v0__fillcap_8
XFILLER_63_492 VDD VDD VSS VSS gf180mcu_fd_sc_mcu7t5v0__fillcap_8
XFILLER_24_868 VDD VDD VSS VSS gf180mcu_fd_sc_mcu7t5v0__fillcap_4
X_3958_ _3958_/D _2279_/I _4098_/CLK _3958_/Q VDD VDD VSS VSS gf180mcu_fd_sc_mcu7t5v0__dffrnq_1
X_3889_ _3889_/D _4148_/RN _4138_/CLK _3889_/Q VDD VDD VSS VSS gf180mcu_fd_sc_mcu7t5v0__dffsnq_1
XTAP_TAPCELL_ROW_21_557 VDD VSS gf180mcu_fd_sc_mcu7t5v0__filltie
XFILLER_104_100 VDD VDD VSS VSS gf180mcu_fd_sc_mcu7t5v0__fillcap_4
XFILLER_132_475 VDD VDD VSS VSS gf180mcu_fd_sc_mcu7t5v0__fill_1
XFILLER_104_166 VDD VDD VSS VSS gf180mcu_fd_sc_mcu7t5v0__fillcap_8
XFILLER_59_710 VDD VDD VSS VSS gf180mcu_fd_sc_mcu7t5v0__fill_1
XFILLER_59_754 VDD VDD VSS VSS gf180mcu_fd_sc_mcu7t5v0__fill_1
XFILLER_19_629 VDD VDD VSS VSS gf180mcu_fd_sc_mcu7t5v0__fill_1
XFILLER_132_31 VDD VDD VSS VSS gf180mcu_fd_sc_mcu7t5v0__fill_2
Xplace57 place57/I _2485_/S VDD VDD VSS VSS gf180mcu_fd_sc_mcu7t5v0__buf_8
XFILLER_73_212 VDD VDD VSS VSS gf180mcu_fd_sc_mcu7t5v0__fillcap_32
Xplace46 place46/I _2728_/S VDD VDD VSS VSS gf180mcu_fd_sc_mcu7t5v0__buf_8
Xplace79 _4091_/Q place79/Z VDD VDD VSS VSS gf180mcu_fd_sc_mcu7t5v0__buf_8
Xplace68 place68/I place68/Z VDD VDD VSS VSS gf180mcu_fd_sc_mcu7t5v0__buf_8
XTAP_TAPCELL_ROW_29_657 VDD VSS gf180mcu_fd_sc_mcu7t5v0__filltie
XTAP_TAPCELL_ROW_29_668 VDD VSS gf180mcu_fd_sc_mcu7t5v0__filltie
XFILLER_61_418 VDD VDD VSS VSS gf180mcu_fd_sc_mcu7t5v0__fill_2
XTAP_TAPCELL_ROW_1_293 VDD VSS gf180mcu_fd_sc_mcu7t5v0__filltie
XTAP_TAPCELL_ROW_64_1113 VDD VSS gf180mcu_fd_sc_mcu7t5v0__filltie
XTAP_TAPCELL_ROW_64_1124 VDD VSS gf180mcu_fd_sc_mcu7t5v0__filltie
XFILLER_14_389 VDD VDD VSS VSS gf180mcu_fd_sc_mcu7t5v0__fill_1
XTAP_TAPCELL_ROW_40_800 VDD VSS gf180mcu_fd_sc_mcu7t5v0__filltie
XTAP_TAPCELL_ROW_40_811 VDD VSS gf180mcu_fd_sc_mcu7t5v0__filltie
XFILLER_41_142 VDD VDD VSS VSS gf180mcu_fd_sc_mcu7t5v0__fillcap_16
XFILLER_41_164 VDD VDD VSS VSS gf180mcu_fd_sc_mcu7t5v0__fill_1
XFILLER_30_849 VDD VDD VSS VSS gf180mcu_fd_sc_mcu7t5v0__fillcap_16
XFILLER_41_197 VDD VDD VSS VSS gf180mcu_fd_sc_mcu7t5v0__fillcap_8
XFILLER_41_72 VDD VDD VSS VSS gf180mcu_fd_sc_mcu7t5v0__fillcap_8
XFILLER_124_932 VDD VDD VSS VSS gf180mcu_fd_sc_mcu7t5v0__fill_2
XTAP_TAPCELL_ROW_75_1264 VDD VSS gf180mcu_fd_sc_mcu7t5v0__filltie
XFILLER_123_486 VDD VDD VSS VSS gf180mcu_fd_sc_mcu7t5v0__fillcap_4
XFILLER_111_626 VDD VDD VSS VSS gf180mcu_fd_sc_mcu7t5v0__fillcap_4
XFILLER_96_337 VDD VDD VSS VSS gf180mcu_fd_sc_mcu7t5v0__fill_2
XFILLER_111_648 VDD VDD VSS VSS gf180mcu_fd_sc_mcu7t5v0__fillcap_8
XFILLER_110_147 VDD VDD VSS VSS gf180mcu_fd_sc_mcu7t5v0__fill_2
XFILLER_77_551 VDD VDD VSS VSS gf180mcu_fd_sc_mcu7t5v0__fill_1
XFILLER_1_282 VDD VDD VSS VSS gf180mcu_fd_sc_mcu7t5v0__fillcap_8
XFILLER_77_562 VDD VDD VSS VSS gf180mcu_fd_sc_mcu7t5v0__fillcap_8
XTAP_TAPCELL_ROW_48_911 VDD VSS gf180mcu_fd_sc_mcu7t5v0__filltie
XFILLER_65_702 VDD VDD VSS VSS gf180mcu_fd_sc_mcu7t5v0__fillcap_64
XTAP_TAPCELL_ROW_127_1939 VDD VSS gf180mcu_fd_sc_mcu7t5v0__filltie
XFILLER_92_554 VDD VDD VSS VSS gf180mcu_fd_sc_mcu7t5v0__fill_1
XFILLER_33_610 VDD VDD VSS VSS gf180mcu_fd_sc_mcu7t5v0__fillcap_4
XFILLER_33_632 VDD VDD VSS VSS gf180mcu_fd_sc_mcu7t5v0__fillcap_64
XFILLER_45_492 VDD VDD VSS VSS gf180mcu_fd_sc_mcu7t5v0__fillcap_8
XFILLER_21_838 VDD VDD VSS VSS gf180mcu_fd_sc_mcu7t5v0__fill_2
X_3812_ _3812_/D clkload9/I _3812_/Q VDD VDD VSS VSS gf180mcu_fd_sc_mcu7t5v0__dffq_1
XPHY_EDGE_ROW_120_Right_120 VDD VSS gf180mcu_fd_sc_mcu7t5v0__endcap
XFILLER_119_726 VDD VDD VSS VSS gf180mcu_fd_sc_mcu7t5v0__fill_2
X_3743_ _3743_/D _3755_/CLK _3743_/Q VDD VDD VSS VSS gf180mcu_fd_sc_mcu7t5v0__dffq_1
XFILLER_118_247 VDD VDD VSS VSS gf180mcu_fd_sc_mcu7t5v0__fillcap_4
X_3674_ _3674_/D _4114_/CLK _3674_/Q VDD VDD VSS VSS gf180mcu_fd_sc_mcu7t5v0__dffq_1
XFILLER_115_932 VDD VDD VSS VSS gf180mcu_fd_sc_mcu7t5v0__fill_2
Xoutput167 _2269_/ZN s_axi_rdata[28] VDD VDD VSS VSS gf180mcu_fd_sc_mcu7t5v0__dlyb_1
Xoutput156 _2249_/ZN s_axi_rdata[18] VDD VDD VSS VSS gf180mcu_fd_sc_mcu7t5v0__dlyb_1
XFILLER_99_142 VDD VDD VSS VSS gf180mcu_fd_sc_mcu7t5v0__fillcap_8
X_2556_ _3748_/Q _4074_/Q _2556_/S _3748_/D VDD VDD VSS VSS gf180mcu_fd_sc_mcu7t5v0__mux2_2
Xoutput145 _4131_/Q s_axi_awready VDD VDD VSS VSS gf180mcu_fd_sc_mcu7t5v0__dlyb_1
Xoutput178 _2227_/ZN s_axi_rdata[9] VDD VDD VSS VSS gf180mcu_fd_sc_mcu7t5v0__dlyb_1
XFILLER_88_849 VDD VDD VSS VSS gf180mcu_fd_sc_mcu7t5v0__fillcap_16
X_2487_ _2360_/Z _2505_/A2 place49/I VDD VDD VSS VSS gf180mcu_fd_sc_mcu7t5v0__nor2_1
XFILLER_102_659 VDD VDD VSS VSS gf180mcu_fd_sc_mcu7t5v0__fillcap_4
XFILLER_101_158 VDD VDD VSS VSS gf180mcu_fd_sc_mcu7t5v0__fillcap_4
XFILLER_96_871 VDD VDD VSS VSS gf180mcu_fd_sc_mcu7t5v0__fillcap_4
X_4157_ _4157_/D _4157_/RN _4157_/CLK _4157_/Q VDD VDD VSS VSS gf180mcu_fd_sc_mcu7t5v0__dffrnq_1
X_3108_ _3995_/Q _3108_/I1 _3160_/S _3995_/D VDD VDD VSS VSS gf180mcu_fd_sc_mcu7t5v0__mux2_2
X_4088_ _4088_/D _2279_/I _4092_/CLK _4088_/Q VDD VDD VSS VSS gf180mcu_fd_sc_mcu7t5v0__dffrnq_1
XFILLER_71_716 VDD VDD VSS VSS gf180mcu_fd_sc_mcu7t5v0__fill_1
X_3039_ _3963_/Q _4051_/Q _3041_/S _3963_/D VDD VDD VSS VSS gf180mcu_fd_sc_mcu7t5v0__mux2_2
XTAP_TAPCELL_ROW_26_627 VDD VSS gf180mcu_fd_sc_mcu7t5v0__filltie
XFILLER_23_142 VDD VDD VSS VSS gf180mcu_fd_sc_mcu7t5v0__fillcap_4
XFILLER_11_348 VDD VDD VSS VSS gf180mcu_fd_sc_mcu7t5v0__fill_2
XFILLER_51_484 VDD VDD VSS VSS gf180mcu_fd_sc_mcu7t5v0__fillcap_4
XPHY_EDGE_ROW_12_Left_145 VDD VSS gf180mcu_fd_sc_mcu7t5v0__endcap
XFILLER_20_871 VDD VDD VSS VSS gf180mcu_fd_sc_mcu7t5v0__fillcap_4
XTAP_TAPCELL_ROW_111_1729 VDD VSS gf180mcu_fd_sc_mcu7t5v0__filltie
XFILLER_87_68 VDD VDD VSS VSS gf180mcu_fd_sc_mcu7t5v0__fill_2
XFILLER_78_304 VDD VDD VSS VSS gf180mcu_fd_sc_mcu7t5v0__fillcap_8
XTAP_TAPCELL_ROW_6_363 VDD VSS gf180mcu_fd_sc_mcu7t5v0__filltie
XPHY_EDGE_ROW_21_Left_154 VDD VSS gf180mcu_fd_sc_mcu7t5v0__endcap
XFILLER_47_702 VDD VDD VSS VSS gf180mcu_fd_sc_mcu7t5v0__fillcap_16
XFILLER_59_562 VDD VDD VSS VSS gf180mcu_fd_sc_mcu7t5v0__fillcap_8
XFILLER_74_521 VDD VDD VSS VSS gf180mcu_fd_sc_mcu7t5v0__fillcap_4
XFILLER_19_415 VDD VDD VSS VSS gf180mcu_fd_sc_mcu7t5v0__fillcap_4
XFILLER_46_212 VDD VDD VSS VSS gf180mcu_fd_sc_mcu7t5v0__fill_2
XTAP_TAPCELL_ROW_70_1194 VDD VSS gf180mcu_fd_sc_mcu7t5v0__filltie
XFILLER_47_768 VDD VDD VSS VSS gf180mcu_fd_sc_mcu7t5v0__fill_2
XFILLER_15_610 VDD VDD VSS VSS gf180mcu_fd_sc_mcu7t5v0__fillcap_16
XFILLER_27_481 VDD VDD VSS VSS gf180mcu_fd_sc_mcu7t5v0__fillcap_8
XFILLER_46_278 VDD VDD VSS VSS gf180mcu_fd_sc_mcu7t5v0__fillcap_32
XFILLER_15_632 VDD VDD VSS VSS gf180mcu_fd_sc_mcu7t5v0__fill_2
XTAP_TAPCELL_ROW_122_1869 VDD VSS gf180mcu_fd_sc_mcu7t5v0__filltie
XFILLER_30_613 VDD VDD VSS VSS gf180mcu_fd_sc_mcu7t5v0__fill_1
XFILLER_42_451 VDD VDD VSS VSS gf180mcu_fd_sc_mcu7t5v0__fillcap_4
XFILLER_15_698 VDD VDD VSS VSS gf180mcu_fd_sc_mcu7t5v0__fill_2
XTAP_TAPCELL_ROW_53_980 VDD VSS gf180mcu_fd_sc_mcu7t5v0__filltie
XFILLER_128_512 VDD VDD VSS VSS gf180mcu_fd_sc_mcu7t5v0__fillcap_8
XPHY_EDGE_ROW_30_Left_163 VDD VSS gf180mcu_fd_sc_mcu7t5v0__endcap
XFILLER_7_842 VDD VDD VSS VSS gf180mcu_fd_sc_mcu7t5v0__fillcap_64
XFILLER_115_206 VDD VDD VSS VSS gf180mcu_fd_sc_mcu7t5v0__fillcap_4
XFILLER_10_381 VDD VDD VSS VSS gf180mcu_fd_sc_mcu7t5v0__fillcap_4
X_2410_ _4073_/Q _3683_/Q _2412_/S _3683_/D VDD VDD VSS VSS gf180mcu_fd_sc_mcu7t5v0__mux2_2
X_3390_ _3390_/A1 _3390_/A2 _3390_/Z VDD VDD VSS VSS gf180mcu_fd_sc_mcu7t5v0__xor2_1
X_2341_ _2540_/A1 _2379_/A2 place60/I VDD VDD VSS VSS gf180mcu_fd_sc_mcu7t5v0__nor2_1
X_2272_ _3931_/Q place72/Z place63/Z _3963_/Q _3971_/Q place67/Z _2273_/I VDD VDD
+ VSS VSS gf180mcu_fd_sc_mcu7t5v0__aoi222_1
X_4011_ _4011_/D _4148_/RN _4146_/CLK _4011_/Q VDD VDD VSS VSS gf180mcu_fd_sc_mcu7t5v0__dffrnq_1
XFILLER_111_489 VDD VDD VSS VSS gf180mcu_fd_sc_mcu7t5v0__fill_1
XTAP_TAPCELL_ROW_88_1433 VDD VSS gf180mcu_fd_sc_mcu7t5v0__filltie
XFILLER_77_370 VDD VDD VSS VSS gf180mcu_fd_sc_mcu7t5v0__fill_1
XFILLER_37_201 VDD VDD VSS VSS gf180mcu_fd_sc_mcu7t5v0__fillcap_8
XFILLER_65_554 VDD VDD VSS VSS gf180mcu_fd_sc_mcu7t5v0__fill_1
XFILLER_92_384 VDD VDD VSS VSS gf180mcu_fd_sc_mcu7t5v0__fill_1
XFILLER_53_727 VDD VDD VSS VSS gf180mcu_fd_sc_mcu7t5v0__fill_1
X_1987_ _4087_/Q _1987_/A2 _1987_/B1 _1987_/B2 _1988_/C VDD VDD VSS VSS gf180mcu_fd_sc_mcu7t5v0__aoi22_1
XTAP_TAPCELL_ROW_31_685 VDD VSS gf180mcu_fd_sc_mcu7t5v0__filltie
X_3726_ _3726_/D _3750_/CLK _3726_/Q VDD VDD VSS VSS gf180mcu_fd_sc_mcu7t5v0__dffq_1
XFILLER_119_578 VDD VDD VSS VSS gf180mcu_fd_sc_mcu7t5v0__fillcap_4
XTAP_TAPCELL_ROW_99_1573 VDD VSS gf180mcu_fd_sc_mcu7t5v0__filltie
X_3657_ _3657_/D _3750_/CLK _3657_/Q VDD VDD VSS VSS gf180mcu_fd_sc_mcu7t5v0__dffq_1
X_3588_ _3763_/Q _3819_/Q _3827_/Q _3835_/Q _4116_/Q place75/Z _3588_/Z VDD VDD VSS
+ VSS gf180mcu_fd_sc_mcu7t5v0__mux4_1
XFILLER_130_776 VDD VDD VSS VSS gf180mcu_fd_sc_mcu7t5v0__fillcap_8
XFILLER_130_765 VDD VDD VSS VSS gf180mcu_fd_sc_mcu7t5v0__fillcap_4
XFILLER_87_156 VDD VDD VSS VSS gf180mcu_fd_sc_mcu7t5v0__fill_1
XFILLER_130_798 VDD VDD VSS VSS gf180mcu_fd_sc_mcu7t5v0__fillcap_4
XTAP_TAPCELL_ROW_3_322 VDD VSS gf180mcu_fd_sc_mcu7t5v0__filltie
XFILLER_28_223 VDD VDD VSS VSS gf180mcu_fd_sc_mcu7t5v0__fill_1
XFILLER_56_521 VDD VDD VSS VSS gf180mcu_fd_sc_mcu7t5v0__fillcap_4
XFILLER_83_340 VDD VDD VSS VSS gf180mcu_fd_sc_mcu7t5v0__fillcap_8
XFILLER_17_908 VDD VDD VSS VSS gf180mcu_fd_sc_mcu7t5v0__fill_2
XFILLER_56_543 VDD VDD VSS VSS gf180mcu_fd_sc_mcu7t5v0__fillcap_4
XFILLER_113_88 VDD VDD VSS VSS gf180mcu_fd_sc_mcu7t5v0__fillcap_4
XFILLER_84_885 VDD VDD VSS VSS gf180mcu_fd_sc_mcu7t5v0__fillcap_4
XTAP_TAPCELL_ROW_39_796 VDD VSS gf180mcu_fd_sc_mcu7t5v0__filltie
XTAP_TAPCELL_ROW_108_1691 VDD VSS gf180mcu_fd_sc_mcu7t5v0__filltie
XFILLER_71_557 VDD VDD VSS VSS gf180mcu_fd_sc_mcu7t5v0__fill_2
XFILLER_43_226 VDD VDD VSS VSS gf180mcu_fd_sc_mcu7t5v0__fill_1
XFILLER_24_451 VDD VDD VSS VSS gf180mcu_fd_sc_mcu7t5v0__fillcap_4
XFILLER_125_2 VDD VDD VSS VSS gf180mcu_fd_sc_mcu7t5v0__fillcap_8
XFILLER_4_801 VDD VDD VSS VSS gf180mcu_fd_sc_mcu7t5v0__fillcap_4
XTAP_TAPCELL_ROW_59_1056 VDD VSS gf180mcu_fd_sc_mcu7t5v0__filltie
XFILLER_121_710 VDD VDD VSS VSS gf180mcu_fd_sc_mcu7t5v0__fillcap_4
XTAP_TAPCELL_ROW_72_1223 VDD VSS gf180mcu_fd_sc_mcu7t5v0__filltie
XFILLER_121_765 VDD VDD VSS VSS gf180mcu_fd_sc_mcu7t5v0__fillcap_4
XFILLER_19_212 VDD VDD VSS VSS gf180mcu_fd_sc_mcu7t5v0__fillcap_32
XFILLER_47_543 VDD VDD VSS VSS gf180mcu_fd_sc_mcu7t5v0__fillcap_16
XFILLER_19_278 VDD VDD VSS VSS gf180mcu_fd_sc_mcu7t5v0__fill_2
XFILLER_90_877 VDD VDD VSS VSS gf180mcu_fd_sc_mcu7t5v0__fillcap_32
XTAP_TAPCELL_ROW_83_1363 VDD VSS gf180mcu_fd_sc_mcu7t5v0__filltie
XFILLER_15_462 VDD VDD VSS VSS gf180mcu_fd_sc_mcu7t5v0__fillcap_4
X_2890_ _4029_/Q _2900_/S _2891_/B VDD VDD VSS VSS gf180mcu_fd_sc_mcu7t5v0__nand2_1
X_1910_ _1910_/I0 _4138_/Q _1910_/S _1910_/Z VDD VDD VSS VSS gf180mcu_fd_sc_mcu7t5v0__mux2_2
X_1841_ _1942_/B _2089_/A1 _1827_/Z _1842_/B VDD VDD VSS VSS gf180mcu_fd_sc_mcu7t5v0__or3_1
XFILLER_129_832 VDD VDD VSS VSS gf180mcu_fd_sc_mcu7t5v0__fillcap_4
XFILLER_128_331 VDD VDD VSS VSS gf180mcu_fd_sc_mcu7t5v0__fillcap_4
XFILLER_8_65 VDD VDD VSS VSS gf180mcu_fd_sc_mcu7t5v0__fillcap_32
XFILLER_129_887 VDD VDD VSS VSS gf180mcu_fd_sc_mcu7t5v0__fill_1
XFILLER_129_865 VDD VDD VSS VSS gf180mcu_fd_sc_mcu7t5v0__fillcap_16
XFILLER_128_353 VDD VDD VSS VSS gf180mcu_fd_sc_mcu7t5v0__fillcap_4
XFILLER_116_515 VDD VDD VSS VSS gf180mcu_fd_sc_mcu7t5v0__fillcap_8
XFILLER_7_694 VDD VDD VSS VSS gf180mcu_fd_sc_mcu7t5v0__fillcap_4
XFILLER_6_171 VDD VDD VSS VSS gf180mcu_fd_sc_mcu7t5v0__fillcap_4
X_3442_ _4100_/Q _4099_/Q _3442_/A3 _3445_/A2 VDD VDD VSS VSS gf180mcu_fd_sc_mcu7t5v0__nand3_1
XFILLER_103_209 VDD VDD VSS VSS gf180mcu_fd_sc_mcu7t5v0__fill_1
XFILLER_98_933 VDD VDD VSS VSS gf180mcu_fd_sc_mcu7t5v0__fill_1
X_3373_ _4085_/Q _3407_/A2 _3372_/Z _4085_/D VDD VDD VSS VSS gf180mcu_fd_sc_mcu7t5v0__xor3_1
XFILLER_40_2 VDD VDD VSS VSS gf180mcu_fd_sc_mcu7t5v0__fillcap_32
X_2324_ place82/Z _3645_/Q _2338_/S _3645_/D VDD VDD VSS VSS gf180mcu_fd_sc_mcu7t5v0__mux2_2
XFILLER_57_318 VDD VDD VSS VSS gf180mcu_fd_sc_mcu7t5v0__fill_2
X_2255_ _2255_/I _2255_/ZN VDD VDD VSS VSS gf180mcu_fd_sc_mcu7t5v0__inv_1
XFILLER_97_487 VDD VDD VSS VSS gf180mcu_fd_sc_mcu7t5v0__fill_2
XFILLER_84_104 VDD VDD VSS VSS gf180mcu_fd_sc_mcu7t5v0__fill_1
XFILLER_38_521 VDD VDD VSS VSS gf180mcu_fd_sc_mcu7t5v0__fillcap_4
X_2186_ _3905_/Q place72/Z place67/Z _4114_/Q _2186_/C _2187_/A3 VDD VDD VSS VSS gf180mcu_fd_sc_mcu7t5v0__aoi221_1
XTAP_TAPCELL_ROW_36_755 VDD VSS gf180mcu_fd_sc_mcu7t5v0__filltie
XFILLER_80_387 VDD VDD VSS VSS gf180mcu_fd_sc_mcu7t5v0__fillcap_16
XFILLER_22_922 VDD VDD VSS VSS gf180mcu_fd_sc_mcu7t5v0__fillcap_8
XTAP_TAPCELL_ROW_16_490 VDD VSS gf180mcu_fd_sc_mcu7t5v0__filltie
X_3709_ _3709_/D _3733_/CLK _3709_/Q VDD VDD VSS VSS gf180mcu_fd_sc_mcu7t5v0__dffq_1
XFILLER_89_900 VDD VDD VSS VSS gf180mcu_fd_sc_mcu7t5v0__fillcap_8
XFILLER_88_443 VDD VDD VSS VSS gf180mcu_fd_sc_mcu7t5v0__fillcap_4
XFILLER_68_37 VDD VDD VSS VSS gf180mcu_fd_sc_mcu7t5v0__fillcap_64
XFILLER_102_242 VDD VDD VSS VSS gf180mcu_fd_sc_mcu7t5v0__fill_2
XFILLER_75_104 VDD VDD VSS VSS gf180mcu_fd_sc_mcu7t5v0__fill_2
XFILLER_91_619 VDD VDD VSS VSS gf180mcu_fd_sc_mcu7t5v0__fillcap_8
XFILLER_84_69 VDD VDD VSS VSS gf180mcu_fd_sc_mcu7t5v0__fillcap_8
XFILLER_44_524 VDD VDD VSS VSS gf180mcu_fd_sc_mcu7t5v0__fill_1
XFILLER_56_351 VDD VDD VSS VSS gf180mcu_fd_sc_mcu7t5v0__fillcap_32
XFILLER_72_877 VDD VDD VSS VSS gf180mcu_fd_sc_mcu7t5v0__fillcap_16
XFILLER_13_933 VDD VDD VSS VSS gf180mcu_fd_sc_mcu7t5v0__fill_1
XFILLER_12_465 VDD VDD VSS VSS gf180mcu_fd_sc_mcu7t5v0__fillcap_4
XFILLER_4_675 VDD VDD VSS VSS gf180mcu_fd_sc_mcu7t5v0__fillcap_4
XFILLER_106_592 VDD VDD VSS VSS gf180mcu_fd_sc_mcu7t5v0__fill_2
XTAP_TAPCELL_ROW_130_1979 VDD VSS gf180mcu_fd_sc_mcu7t5v0__filltie
XFILLER_121_562 VDD VDD VSS VSS gf180mcu_fd_sc_mcu7t5v0__fill_2
XFILLER_66_104 VDD VDD VSS VSS gf180mcu_fd_sc_mcu7t5v0__fill_1
X_2040_ _2008_/Z _2040_/A2 _2040_/B _4136_/D VDD VDD VSS VSS gf180mcu_fd_sc_mcu7t5v0__oai21_4
XFILLER_94_457 VDD VDD VSS VSS gf180mcu_fd_sc_mcu7t5v0__fill_2
XFILLER_48_874 VDD VDD VSS VSS gf180mcu_fd_sc_mcu7t5v0__fill_1
XFILLER_74_192 VDD VDD VSS VSS gf180mcu_fd_sc_mcu7t5v0__fillcap_32
XFILLER_35_568 VDD VDD VSS VSS gf180mcu_fd_sc_mcu7t5v0__fill_1
X_3991_ _3991_/D input92/Z _4023_/CLK _3991_/Q VDD VDD VSS VSS gf180mcu_fd_sc_mcu7t5v0__dffrnq_1
XTAP_TAPCELL_ROW_33_714 VDD VSS gf180mcu_fd_sc_mcu7t5v0__filltie
XFILLER_50_527 VDD VDD VSS VSS gf180mcu_fd_sc_mcu7t5v0__fillcap_32
XFILLER_62_387 VDD VDD VSS VSS gf180mcu_fd_sc_mcu7t5v0__fillcap_16
XTAP_TAPCELL_ROW_13_460 VDD VSS gf180mcu_fd_sc_mcu7t5v0__filltie
XFILLER_30_273 VDD VDD VSS VSS gf180mcu_fd_sc_mcu7t5v0__fill_1
X_1824_ _1824_/I0 _1824_/I1 _1948_/C _1824_/Z VDD VDD VSS VSS gf180mcu_fd_sc_mcu7t5v0__mux2_2
XFILLER_129_695 VDD VDD VSS VSS gf180mcu_fd_sc_mcu7t5v0__fill_1
XFILLER_129_673 VDD VDD VSS VSS gf180mcu_fd_sc_mcu7t5v0__fillcap_16
XFILLER_117_835 VDD VDD VSS VSS gf180mcu_fd_sc_mcu7t5v0__fillcap_4
XFILLER_117_846 VDD VDD VSS VSS gf180mcu_fd_sc_mcu7t5v0__fill_1
XTAP_TAPCELL_ROW_96_1532 VDD VSS gf180mcu_fd_sc_mcu7t5v0__filltie
X_3425_ _3420_/Z _3425_/A2 _3449_/C _3901_/Q _3444_/A1 VDD VDD VSS VSS gf180mcu_fd_sc_mcu7t5v0__oai211_1
X_3287_ _4162_/Q _4164_/Q _3287_/A3 _3288_/A2 VDD VDD VSS VSS gf180mcu_fd_sc_mcu7t5v0__xnor3_1
X_2307_ _3638_/Q _4068_/Q _2319_/S _3638_/D VDD VDD VSS VSS gf180mcu_fd_sc_mcu7t5v0__mux2_2
X_2238_ _3898_/Q place68/Z place63/Z _3946_/Q _3914_/Q place72/Z _2239_/I VDD VDD
+ VSS VSS gf180mcu_fd_sc_mcu7t5v0__aoi222_1
XFILLER_100_757 VDD VDD VSS VSS gf180mcu_fd_sc_mcu7t5v0__fill_1
XFILLER_85_468 VDD VDD VSS VSS gf180mcu_fd_sc_mcu7t5v0__fillcap_8
XFILLER_66_660 VDD VDD VSS VSS gf180mcu_fd_sc_mcu7t5v0__fillcap_4
XFILLER_72_107 VDD VDD VSS VSS gf180mcu_fd_sc_mcu7t5v0__fillcap_32
X_2169_ _3904_/Q place72/Z place68/Z _3888_/Q _2169_/C _2170_/A3 VDD VDD VSS VSS gf180mcu_fd_sc_mcu7t5v0__aoi221_1
XFILLER_54_855 VDD VDD VSS VSS gf180mcu_fd_sc_mcu7t5v0__fillcap_4
XTAP_TAPCELL_ROW_105_1650 VDD VSS gf180mcu_fd_sc_mcu7t5v0__filltie
XFILLER_54_877 VDD VDD VSS VSS gf180mcu_fd_sc_mcu7t5v0__fillcap_4
XFILLER_81_696 VDD VDD VSS VSS gf180mcu_fd_sc_mcu7t5v0__fillcap_4
XFILLER_41_538 VDD VDD VSS VSS gf180mcu_fd_sc_mcu7t5v0__fillcap_16
XFILLER_53_398 VDD VDD VSS VSS gf180mcu_fd_sc_mcu7t5v0__fill_1
XFILLER_110_45 VDD VDD VSS VSS gf180mcu_fd_sc_mcu7t5v0__fillcap_4
XFILLER_10_925 VDD VDD VSS VSS gf180mcu_fd_sc_mcu7t5v0__fillcap_8
XFILLER_70_27 VDD VDD VSS VSS gf180mcu_fd_sc_mcu7t5v0__fillcap_8
XFILLER_70_49 VDD VDD VSS VSS gf180mcu_fd_sc_mcu7t5v0__fill_2
XFILLER_119_172 VDD VDD VSS VSS gf180mcu_fd_sc_mcu7t5v0__fill_1
XFILLER_5_428 VDD VDD VSS VSS gf180mcu_fd_sc_mcu7t5v0__fill_1
XTAP_TAPCELL_ROW_56_1015 VDD VSS gf180mcu_fd_sc_mcu7t5v0__filltie
XTAP_TAPCELL_ROW_116_1790 VDD VSS gf180mcu_fd_sc_mcu7t5v0__filltie
XFILLER_103_562 VDD VDD VSS VSS gf180mcu_fd_sc_mcu7t5v0__fillcap_16
XFILLER_76_413 VDD VDD VSS VSS gf180mcu_fd_sc_mcu7t5v0__fillcap_32
XFILLER_76_457 VDD VDD VSS VSS gf180mcu_fd_sc_mcu7t5v0__fillcap_4
XFILLER_91_438 VDD VDD VSS VSS gf180mcu_fd_sc_mcu7t5v0__fillcap_8
XFILLER_29_395 VDD VDD VSS VSS gf180mcu_fd_sc_mcu7t5v0__fill_2
XFILLER_44_343 VDD VDD VSS VSS gf180mcu_fd_sc_mcu7t5v0__fill_2
XFILLER_44_354 VDD VDD VSS VSS gf180mcu_fd_sc_mcu7t5v0__fillcap_16
XFILLER_60_803 VDD VDD VSS VSS gf180mcu_fd_sc_mcu7t5v0__fill_2
XTAP_TAPCELL_ROW_67_1155 VDD VSS gf180mcu_fd_sc_mcu7t5v0__filltie
XFILLER_32_527 VDD VDD VSS VSS gf180mcu_fd_sc_mcu7t5v0__fillcap_64
XFILLER_44_387 VDD VDD VSS VSS gf180mcu_fd_sc_mcu7t5v0__fillcap_32
XTAP_TAPCELL_ROW_80_1322 VDD VSS gf180mcu_fd_sc_mcu7t5v0__filltie
XFILLER_60_869 VDD VDD VSS VSS gf180mcu_fd_sc_mcu7t5v0__fillcap_4
XPHY_EDGE_ROW_4_Left_137 VDD VSS gf180mcu_fd_sc_mcu7t5v0__endcap
XFILLER_9_767 VDD VDD VSS VSS gf180mcu_fd_sc_mcu7t5v0__fill_2
XTAP_TAPCELL_ROW_78_1295 VDD VSS gf180mcu_fd_sc_mcu7t5v0__filltie
XTAP_TAPCELL_ROW_91_1473 VDD VSS gf180mcu_fd_sc_mcu7t5v0__filltie
XFILLER_95_766 VDD VDD VSS VSS gf180mcu_fd_sc_mcu7t5v0__fillcap_4
XFILLER_94_243 VDD VDD VSS VSS gf180mcu_fd_sc_mcu7t5v0__fill_2
XFILLER_67_435 VDD VDD VSS VSS gf180mcu_fd_sc_mcu7t5v0__fillcap_8
XFILLER_95_788 VDD VDD VSS VSS gf180mcu_fd_sc_mcu7t5v0__fillcap_4
XFILLER_83_928 VDD VDD VSS VSS gf180mcu_fd_sc_mcu7t5v0__fillcap_4
XFILLER_82_405 VDD VDD VSS VSS gf180mcu_fd_sc_mcu7t5v0__fill_1
X_2023_ _4133_/Q _4132_/Q _2024_/A2 VDD VDD VSS VSS gf180mcu_fd_sc_mcu7t5v0__nand2_1
XFILLER_36_877 VDD VDD VSS VSS gf180mcu_fd_sc_mcu7t5v0__fillcap_16
XTAP_TAPCELL_ROW_46_883 VDD VSS gf180mcu_fd_sc_mcu7t5v0__filltie
X_3974_ _3974_/D _4157_/RN _3975_/CLK _3974_/Q VDD VDD VSS VSS gf180mcu_fd_sc_mcu7t5v0__dffsnq_1
XTAP_TAPCELL_ROW_100_1580 VDD VSS gf180mcu_fd_sc_mcu7t5v0__filltie
XTAP_TAPCELL_ROW_100_1591 VDD VSS gf180mcu_fd_sc_mcu7t5v0__filltie
XFILLER_129_492 VDD VDD VSS VSS gf180mcu_fd_sc_mcu7t5v0__fill_2
XFILLER_117_632 VDD VDD VSS VSS gf180mcu_fd_sc_mcu7t5v0__fillcap_32
Xhold211 s_axi_wdata[26] hold211/Z VDD VDD VSS VSS gf180mcu_fd_sc_mcu7t5v0__dlyc_1
Xhold200 s_axi_wdata[20] hold200/Z VDD VDD VSS VSS gf180mcu_fd_sc_mcu7t5v0__dlyc_1
X_2787_ place89/Z _3846_/Q _2799_/S _3846_/D VDD VDD VSS VSS gf180mcu_fd_sc_mcu7t5v0__mux2_2
Xhold222 s_axi_wdata[9] hold222/Z VDD VDD VSS VSS gf180mcu_fd_sc_mcu7t5v0__dlyc_1
XFILLER_59_903 VDD VDD VSS VSS gf180mcu_fd_sc_mcu7t5v0__fillcap_4
XFILLER_98_593 VDD VDD VSS VSS gf180mcu_fd_sc_mcu7t5v0__fill_2
XFILLER_100_521 VDD VDD VSS VSS gf180mcu_fd_sc_mcu7t5v0__fillcap_4
X_3339_ _3340_/A2 _3319_/B _3339_/B _3353_/B _3341_/A2 VDD VDD VSS VSS gf180mcu_fd_sc_mcu7t5v0__oai211_1
XFILLER_58_457 VDD VDD VSS VSS gf180mcu_fd_sc_mcu7t5v0__fill_1
XFILLER_105_67 VDD VDD VSS VSS gf180mcu_fd_sc_mcu7t5v0__fill_2
XFILLER_85_265 VDD VDD VSS VSS gf180mcu_fd_sc_mcu7t5v0__fill_1
XFILLER_73_416 VDD VDD VSS VSS gf180mcu_fd_sc_mcu7t5v0__fillcap_4
XFILLER_38_170 VDD VDD VSS VSS gf180mcu_fd_sc_mcu7t5v0__fillcap_4
XFILLER_26_332 VDD VDD VSS VSS gf180mcu_fd_sc_mcu7t5v0__fillcap_32
XFILLER_54_641 VDD VDD VSS VSS gf180mcu_fd_sc_mcu7t5v0__fill_2
XFILLER_121_66 VDD VDD VSS VSS gf180mcu_fd_sc_mcu7t5v0__fillcap_4
XFILLER_81_26 VDD VDD VSS VSS gf180mcu_fd_sc_mcu7t5v0__fill_2
XFILLER_26_387 VDD VDD VSS VSS gf180mcu_fd_sc_mcu7t5v0__fillcap_64
XFILLER_27_899 VDD VDD VSS VSS gf180mcu_fd_sc_mcu7t5v0__fillcap_8
XFILLER_41_346 VDD VDD VSS VSS gf180mcu_fd_sc_mcu7t5v0__fillcap_4
XFILLER_41_368 VDD VDD VSS VSS gf180mcu_fd_sc_mcu7t5v0__fillcap_4
XFILLER_22_593 VDD VDD VSS VSS gf180mcu_fd_sc_mcu7t5v0__fill_2
XTAP_TAPCELL_ROW_24_599 VDD VSS gf180mcu_fd_sc_mcu7t5v0__filltie
XTAP_TAPCELL_ROW_62_1096 VDD VSS gf180mcu_fd_sc_mcu7t5v0__filltie
XFILLER_6_704 VDD VDD VSS VSS gf180mcu_fd_sc_mcu7t5v0__fillcap_16
XFILLER_108_643 VDD VDD VSS VSS gf180mcu_fd_sc_mcu7t5v0__fillcap_16
XFILLER_6_737 VDD VDD VSS VSS gf180mcu_fd_sc_mcu7t5v0__fillcap_16
XFILLER_108_676 VDD VDD VSS VSS gf180mcu_fd_sc_mcu7t5v0__fillcap_32
XFILLER_107_142 VDD VDD VSS VSS gf180mcu_fd_sc_mcu7t5v0__fillcap_64
XFILLER_122_101 VDD VDD VSS VSS gf180mcu_fd_sc_mcu7t5v0__fillcap_4
XFILLER_30_85 VDD VDD VSS VSS gf180mcu_fd_sc_mcu7t5v0__fillcap_4
XFILLER_104_893 VDD VDD VSS VSS gf180mcu_fd_sc_mcu7t5v0__fillcap_8
XFILLER_104_871 VDD VDD VSS VSS gf180mcu_fd_sc_mcu7t5v0__fillcap_4
XFILLER_1_486 VDD VDD VSS VSS gf180mcu_fd_sc_mcu7t5v0__fillcap_4
XFILLER_39_72 VDD VDD VSS VSS gf180mcu_fd_sc_mcu7t5v0__fillcap_8
XFILLER_65_906 VDD VDD VSS VSS gf180mcu_fd_sc_mcu7t5v0__fillcap_4
XFILLER_92_703 VDD VDD VSS VSS gf180mcu_fd_sc_mcu7t5v0__fill_2
XFILLER_18_800 VDD VDD VSS VSS gf180mcu_fd_sc_mcu7t5v0__fillcap_4
XFILLER_36_107 VDD VDD VSS VSS gf180mcu_fd_sc_mcu7t5v0__fillcap_8
XFILLER_37_619 VDD VDD VSS VSS gf180mcu_fd_sc_mcu7t5v0__fillcap_8
XFILLER_65_928 VDD VDD VSS VSS gf180mcu_fd_sc_mcu7t5v0__fillcap_4
XPHY_EDGE_ROW_101_Right_101 VDD VSS gf180mcu_fd_sc_mcu7t5v0__endcap
XFILLER_92_769 VDD VDD VSS VSS gf180mcu_fd_sc_mcu7t5v0__fillcap_16
Xclkbuf_leaf_56_clk clkbuf_leaf_5_clk/I _4129_/CLK VDD VDD VSS VSS gf180mcu_fd_sc_mcu7t5v0__clkbuf_8
XFILLER_18_877 VDD VDD VSS VSS gf180mcu_fd_sc_mcu7t5v0__fillcap_16
XFILLER_18_899 VDD VDD VSS VSS gf180mcu_fd_sc_mcu7t5v0__fill_1
XFILLER_33_836 VDD VDD VSS VSS gf180mcu_fd_sc_mcu7t5v0__fillcap_4
XFILLER_44_173 VDD VDD VSS VSS gf180mcu_fd_sc_mcu7t5v0__fill_2
XTAP_TAPCELL_ROW_43_842 VDD VSS gf180mcu_fd_sc_mcu7t5v0__filltie
XFILLER_60_699 VDD VDD VSS VSS gf180mcu_fd_sc_mcu7t5v0__fillcap_4
X_2710_ place83/Z _3812_/Q _2710_/S _3812_/D VDD VDD VSS VSS gf180mcu_fd_sc_mcu7t5v0__mux2_2
X_3690_ _3690_/D _3733_/CLK _3690_/Q VDD VDD VSS VSS gf180mcu_fd_sc_mcu7t5v0__dffq_1
X_2641_ _4122_/Q _3540_/A1 VDD VDD VSS VSS gf180mcu_fd_sc_mcu7t5v0__clkinv_1
XFILLER_126_451 VDD VDD VSS VSS gf180mcu_fd_sc_mcu7t5v0__fillcap_4
X_2572_ _3755_/Q _4073_/Q _2574_/S _3755_/D VDD VDD VSS VSS gf180mcu_fd_sc_mcu7t5v0__mux2_2
XFILLER_114_646 VDD VDD VSS VSS gf180mcu_fd_sc_mcu7t5v0__fillcap_4
XFILLER_113_134 VDD VDD VSS VSS gf180mcu_fd_sc_mcu7t5v0__fillcap_4
XFILLER_99_346 VDD VDD VSS VSS gf180mcu_fd_sc_mcu7t5v0__fillcap_4
XFILLER_4_280 VDD VDD VSS VSS gf180mcu_fd_sc_mcu7t5v0__fillcap_16
XFILLER_110_874 VDD VDD VSS VSS gf180mcu_fd_sc_mcu7t5v0__fill_1
XFILLER_55_416 VDD VDD VSS VSS gf180mcu_fd_sc_mcu7t5v0__fillcap_4
XFILLER_82_235 VDD VDD VSS VSS gf180mcu_fd_sc_mcu7t5v0__fillcap_4
XFILLER_83_769 VDD VDD VSS VSS gf180mcu_fd_sc_mcu7t5v0__fill_1
X_2006_ _4127_/Q _4115_/Q _4090_/Q _2007_/B VDD VDD VSS VSS gf180mcu_fd_sc_mcu7t5v0__nor3_1
XFILLER_24_803 VDD VDD VSS VSS gf180mcu_fd_sc_mcu7t5v0__fill_2
Xclkbuf_leaf_47_clk clkload3/I _4076_/CLK VDD VDD VSS VSS gf180mcu_fd_sc_mcu7t5v0__clkbuf_8
XFILLER_91_791 VDD VDD VSS VSS gf180mcu_fd_sc_mcu7t5v0__fill_2
XFILLER_24_836 VDD VDD VSS VSS gf180mcu_fd_sc_mcu7t5v0__fillcap_32
XFILLER_23_346 VDD VDD VSS VSS gf180mcu_fd_sc_mcu7t5v0__fillcap_4
XFILLER_51_644 VDD VDD VSS VSS gf180mcu_fd_sc_mcu7t5v0__fill_1
X_3957_ _3957_/D _2279_/I _4125_/CLK _3957_/Q VDD VDD VSS VSS gf180mcu_fd_sc_mcu7t5v0__dffrnq_1
X_2908_ place90/Z _3901_/Q _2972_/S _3901_/D VDD VDD VSS VSS gf180mcu_fd_sc_mcu7t5v0__mux2_2
X_3888_ _3888_/D _4148_/RN _4138_/CLK _3888_/Q VDD VDD VSS VSS gf180mcu_fd_sc_mcu7t5v0__dffsnq_1
XTAP_TAPCELL_ROW_21_558 VDD VSS gf180mcu_fd_sc_mcu7t5v0__filltie
XFILLER_117_462 VDD VDD VSS VSS gf180mcu_fd_sc_mcu7t5v0__fillcap_8
XPHY_EDGE_ROW_76_Left_209 VDD VSS gf180mcu_fd_sc_mcu7t5v0__endcap
XFILLER_132_410 VDD VDD VSS VSS gf180mcu_fd_sc_mcu7t5v0__fillcap_32
XFILLER_132_454 VDD VDD VSS VSS gf180mcu_fd_sc_mcu7t5v0__fill_1
XTAP_TAPCELL_ROW_113_1760 VDD VSS gf180mcu_fd_sc_mcu7t5v0__filltie
XFILLER_76_37 VDD VDD VSS VSS gf180mcu_fd_sc_mcu7t5v0__fill_2
XFILLER_86_585 VDD VDD VSS VSS gf180mcu_fd_sc_mcu7t5v0__fillcap_8
XFILLER_74_725 VDD VDD VSS VSS gf180mcu_fd_sc_mcu7t5v0__fillcap_8
XFILLER_47_928 VDD VDD VSS VSS gf180mcu_fd_sc_mcu7t5v0__fillcap_4
XFILLER_100_384 VDD VDD VSS VSS gf180mcu_fd_sc_mcu7t5v0__fill_1
Xplace47 place47/I _2598_/S VDD VDD VSS VSS gf180mcu_fd_sc_mcu7t5v0__buf_8
XFILLER_58_298 VDD VDD VSS VSS gf180mcu_fd_sc_mcu7t5v0__fillcap_16
Xplace69 _4130_/D _3160_/S VDD VDD VSS VSS gf180mcu_fd_sc_mcu7t5v0__buf_8
Xplace58 place58/I _2448_/S VDD VDD VSS VSS gf180mcu_fd_sc_mcu7t5v0__buf_8
XPHY_EDGE_ROW_85_Left_218 VDD VSS gf180mcu_fd_sc_mcu7t5v0__endcap
XFILLER_74_769 VDD VDD VSS VSS gf180mcu_fd_sc_mcu7t5v0__fillcap_32
XFILLER_73_268 VDD VDD VSS VSS gf180mcu_fd_sc_mcu7t5v0__fillcap_4
XTAP_TAPCELL_ROW_29_658 VDD VSS gf180mcu_fd_sc_mcu7t5v0__filltie
XTAP_TAPCELL_ROW_29_669 VDD VSS gf180mcu_fd_sc_mcu7t5v0__filltie
Xclkbuf_leaf_38_clk clkload4/I _3729_/CLK VDD VDD VSS VSS gf180mcu_fd_sc_mcu7t5v0__clkbuf_8
XFILLER_15_825 VDD VDD VSS VSS gf180mcu_fd_sc_mcu7t5v0__fillcap_8
XTAP_TAPCELL_ROW_1_294 VDD VSS gf180mcu_fd_sc_mcu7t5v0__filltie
XFILLER_25_30 VDD VDD VSS VSS gf180mcu_fd_sc_mcu7t5v0__fill_1
XTAP_TAPCELL_ROW_64_1114 VDD VSS gf180mcu_fd_sc_mcu7t5v0__filltie
XFILLER_15_858 VDD VDD VSS VSS gf180mcu_fd_sc_mcu7t5v0__fillcap_8
XFILLER_54_493 VDD VDD VSS VSS gf180mcu_fd_sc_mcu7t5v0__fill_1
XFILLER_25_96 VDD VDD VSS VSS gf180mcu_fd_sc_mcu7t5v0__fill_2
XTAP_TAPCELL_ROW_40_801 VDD VSS gf180mcu_fd_sc_mcu7t5v0__filltie
XTAP_TAPCELL_ROW_40_812 VDD VSS gf180mcu_fd_sc_mcu7t5v0__filltie
XPHY_EDGE_ROW_94_Left_227 VDD VSS gf180mcu_fd_sc_mcu7t5v0__endcap
XFILLER_10_585 VDD VDD VSS VSS gf180mcu_fd_sc_mcu7t5v0__fillcap_8
XFILLER_41_84 VDD VDD VSS VSS gf180mcu_fd_sc_mcu7t5v0__fill_2
XFILLER_127_259 VDD VDD VSS VSS gf180mcu_fd_sc_mcu7t5v0__fillcap_16
XFILLER_108_451 VDD VDD VSS VSS gf180mcu_fd_sc_mcu7t5v0__fillcap_4
XFILLER_6_589 VDD VDD VSS VSS gf180mcu_fd_sc_mcu7t5v0__fillcap_4
XTAP_TAPCELL_ROW_75_1265 VDD VSS gf180mcu_fd_sc_mcu7t5v0__filltie
XFILLER_69_508 VDD VDD VSS VSS gf180mcu_fd_sc_mcu7t5v0__fill_1
XFILLER_97_839 VDD VDD VSS VSS gf180mcu_fd_sc_mcu7t5v0__fill_1
XFILLER_1_294 VDD VDD VSS VSS gf180mcu_fd_sc_mcu7t5v0__fill_2
XFILLER_2_795 VDD VDD VSS VSS gf180mcu_fd_sc_mcu7t5v0__fillcap_8
XTAP_TAPCELL_ROW_48_912 VDD VSS gf180mcu_fd_sc_mcu7t5v0__filltie
XFILLER_92_511 VDD VDD VSS VSS gf180mcu_fd_sc_mcu7t5v0__fillcap_4
XFILLER_37_416 VDD VDD VSS VSS gf180mcu_fd_sc_mcu7t5v0__fillcap_4
XFILLER_37_438 VDD VDD VSS VSS gf180mcu_fd_sc_mcu7t5v0__fillcap_4
XFILLER_49_276 VDD VDD VSS VSS gf180mcu_fd_sc_mcu7t5v0__fillcap_4
Xclkbuf_leaf_29_clk clkload6/I _4098_/CLK VDD VDD VSS VSS gf180mcu_fd_sc_mcu7t5v0__clkbuf_8
XFILLER_61_931 VDD VDD VSS VSS gf180mcu_fd_sc_mcu7t5v0__fill_2
X_3811_ _3811_/D clkload7/I _3811_/Q VDD VDD VSS VSS gf180mcu_fd_sc_mcu7t5v0__dffq_1
XFILLER_32_154 VDD VDD VSS VSS gf180mcu_fd_sc_mcu7t5v0__fillcap_16
XFILLER_14_891 VDD VDD VSS VSS gf180mcu_fd_sc_mcu7t5v0__fill_1
X_3742_ _3742_/D _3750_/CLK _3742_/Q VDD VDD VSS VSS gf180mcu_fd_sc_mcu7t5v0__dffq_1
XFILLER_118_215 VDD VDD VSS VSS gf180mcu_fd_sc_mcu7t5v0__fill_2
X_3673_ _3673_/D _4076_/CLK _3673_/Q VDD VDD VSS VSS gf180mcu_fd_sc_mcu7t5v0__dffq_1
X_2624_ place90/Z _3773_/Q _2638_/S _3773_/D VDD VDD VSS VSS gf180mcu_fd_sc_mcu7t5v0__mux2_2
Xoutput168 _2271_/ZN s_axi_rdata[29] VDD VDD VSS VSS gf180mcu_fd_sc_mcu7t5v0__dlyb_1
Xoutput157 _2251_/ZN s_axi_rdata[19] VDD VDD VSS VSS gf180mcu_fd_sc_mcu7t5v0__dlyb_1
Xoutput146 _4059_/Q s_axi_bvalid VDD VDD VSS VSS gf180mcu_fd_sc_mcu7t5v0__dlyb_1
XFILLER_99_154 VDD VDD VSS VSS gf180mcu_fd_sc_mcu7t5v0__fill_1
XFILLER_88_817 VDD VDD VSS VSS gf180mcu_fd_sc_mcu7t5v0__fillcap_32
Xoutput179 _4060_/Q s_axi_rvalid VDD VDD VSS VSS gf180mcu_fd_sc_mcu7t5v0__dlyb_1
XFILLER_87_349 VDD VDD VSS VSS gf180mcu_fd_sc_mcu7t5v0__fill_1
XFILLER_29_906 VDD VDD VSS VSS gf180mcu_fd_sc_mcu7t5v0__fillcap_4
XFILLER_29_928 VDD VDD VSS VSS gf180mcu_fd_sc_mcu7t5v0__fillcap_4
X_4156_ _4156_/D _4157_/RN _4156_/CLK _4156_/Q VDD VDD VSS VSS gf180mcu_fd_sc_mcu7t5v0__dffrnq_1
XFILLER_110_682 VDD VDD VSS VSS gf180mcu_fd_sc_mcu7t5v0__fillcap_32
X_4087_ _4087_/D _2279_/I _4092_/CLK _4087_/Q VDD VDD VSS VSS gf180mcu_fd_sc_mcu7t5v0__dffrnq_1
XTAP_TAPCELL_ROW_26_628 VDD VSS gf180mcu_fd_sc_mcu7t5v0__filltie
XFILLER_51_430 VDD VDD VSS VSS gf180mcu_fd_sc_mcu7t5v0__fillcap_4
XFILLER_106_933 VDD VDD VSS VSS gf180mcu_fd_sc_mcu7t5v0__fill_1
XFILLER_132_240 VDD VDD VSS VSS gf180mcu_fd_sc_mcu7t5v0__fillcap_32
XFILLER_120_424 VDD VDD VSS VSS gf180mcu_fd_sc_mcu7t5v0__fillcap_16
XFILLER_87_850 VDD VDD VSS VSS gf180mcu_fd_sc_mcu7t5v0__fillcap_4
XFILLER_120_457 VDD VDD VSS VSS gf180mcu_fd_sc_mcu7t5v0__fillcap_16
XTAP_TAPCELL_ROW_6_364 VDD VSS gf180mcu_fd_sc_mcu7t5v0__filltie
XFILLER_59_574 VDD VDD VSS VSS gf180mcu_fd_sc_mcu7t5v0__fill_2
XFILLER_86_382 VDD VDD VSS VSS gf180mcu_fd_sc_mcu7t5v0__fill_2
XTAP_TAPCELL_ROW_70_1195 VDD VSS gf180mcu_fd_sc_mcu7t5v0__filltie
XFILLER_35_909 VDD VDD VSS VSS gf180mcu_fd_sc_mcu7t5v0__fill_1
XTAP_TAPCELL_ROW_53_970 VDD VSS gf180mcu_fd_sc_mcu7t5v0__filltie
XTAP_TAPCELL_ROW_53_981 VDD VSS gf180mcu_fd_sc_mcu7t5v0__filltie
XFILLER_52_61 VDD VDD VSS VSS gf180mcu_fd_sc_mcu7t5v0__fill_1
XFILLER_128_524 VDD VDD VSS VSS gf180mcu_fd_sc_mcu7t5v0__fill_1
XFILLER_128_579 VDD VDD VSS VSS gf180mcu_fd_sc_mcu7t5v0__fill_1
XFILLER_112_925 VDD VDD VSS VSS gf180mcu_fd_sc_mcu7t5v0__fillcap_8
XFILLER_97_625 VDD VDD VSS VSS gf180mcu_fd_sc_mcu7t5v0__fillcap_4
X_2340_ _4097_/Q _4098_/Q _2379_/A2 VDD VDD VSS VSS gf180mcu_fd_sc_mcu7t5v0__nand2_1
X_2271_ _2271_/I _2271_/ZN VDD VDD VSS VSS gf180mcu_fd_sc_mcu7t5v0__inv_1
XFILLER_111_446 VDD VDD VSS VSS gf180mcu_fd_sc_mcu7t5v0__fill_2
X_4010_ _4010_/D input92/Z _4130_/CLK _4010_/Q VDD VDD VSS VSS gf180mcu_fd_sc_mcu7t5v0__dffrnq_1
XFILLER_96_157 VDD VDD VSS VSS gf180mcu_fd_sc_mcu7t5v0__fillcap_4
XFILLER_93_842 VDD VDD VSS VSS gf180mcu_fd_sc_mcu7t5v0__fillcap_4
XTAP_TAPCELL_ROW_88_1434 VDD VSS gf180mcu_fd_sc_mcu7t5v0__filltie
XFILLER_38_769 VDD VDD VSS VSS gf180mcu_fd_sc_mcu7t5v0__fillcap_16
XFILLER_34_920 VDD VDD VSS VSS gf180mcu_fd_sc_mcu7t5v0__fillcap_8
XFILLER_37_279 VDD VDD VSS VSS gf180mcu_fd_sc_mcu7t5v0__fill_1
XFILLER_53_717 VDD VDD VSS VSS gf180mcu_fd_sc_mcu7t5v0__fillcap_8
XFILLER_20_102 VDD VDD VSS VSS gf180mcu_fd_sc_mcu7t5v0__fill_2
XFILLER_21_636 VDD VDD VSS VSS gf180mcu_fd_sc_mcu7t5v0__fill_1
X_1986_ _3385_/A2 _3966_/Q _3965_/Q _1986_/C _1987_/B2 VDD VDD VSS VSS gf180mcu_fd_sc_mcu7t5v0__oai211_1
XFILLER_119_524 VDD VDD VSS VSS gf180mcu_fd_sc_mcu7t5v0__fill_1
X_3725_ _3725_/D _3733_/CLK _3725_/Q VDD VDD VSS VSS gf180mcu_fd_sc_mcu7t5v0__dffq_1
XFILLER_20_168 VDD VDD VSS VSS gf180mcu_fd_sc_mcu7t5v0__fillcap_4
XTAP_TAPCELL_ROW_31_686 VDD VSS gf180mcu_fd_sc_mcu7t5v0__filltie
XFILLER_119_557 VDD VDD VSS VSS gf180mcu_fd_sc_mcu7t5v0__fill_2
XTAP_TAPCELL_ROW_99_1574 VDD VSS gf180mcu_fd_sc_mcu7t5v0__filltie
Xclkbuf_leaf_9_clk clkload1/I _4057_/CLK VDD VDD VSS VSS gf180mcu_fd_sc_mcu7t5v0__clkbuf_8
X_3656_ _3656_/D _4108_/CLK _3656_/Q VDD VDD VSS VSS gf180mcu_fd_sc_mcu7t5v0__dffq_1
X_2607_ place89/Z _3766_/Q _2619_/S _3766_/D VDD VDD VSS VSS gf180mcu_fd_sc_mcu7t5v0__mux2_2
XFILLER_130_711 VDD VDD VSS VSS gf180mcu_fd_sc_mcu7t5v0__fillcap_16
XFILLER_0_507 VDD VDD VSS VSS gf180mcu_fd_sc_mcu7t5v0__fill_2
X_2538_ _4074_/Q _3740_/Q _2538_/S _3740_/D VDD VDD VSS VSS gf180mcu_fd_sc_mcu7t5v0__mux2_2
XFILLER_130_733 VDD VDD VSS VSS gf180mcu_fd_sc_mcu7t5v0__fill_2
XFILLER_102_457 VDD VDD VSS VSS gf180mcu_fd_sc_mcu7t5v0__fillcap_64
X_2469_ _2540_/A1 _2505_/A2 place57/I VDD VDD VSS VSS gf180mcu_fd_sc_mcu7t5v0__nor2_1
XTAP_TAPCELL_ROW_3_323 VDD VSS gf180mcu_fd_sc_mcu7t5v0__filltie
XFILLER_69_894 VDD VDD VSS VSS gf180mcu_fd_sc_mcu7t5v0__fill_1
X_4139_ _4139_/D _4148_/RN _4145_/CLK _4139_/Q VDD VDD VSS VSS gf180mcu_fd_sc_mcu7t5v0__dffrnq_1
XFILLER_84_853 VDD VDD VSS VSS gf180mcu_fd_sc_mcu7t5v0__fillcap_16
XFILLER_56_555 VDD VDD VSS VSS gf180mcu_fd_sc_mcu7t5v0__fillcap_8
XFILLER_83_352 VDD VDD VSS VSS gf180mcu_fd_sc_mcu7t5v0__fillcap_4
XFILLER_56_588 VDD VDD VSS VSS gf180mcu_fd_sc_mcu7t5v0__fillcap_4
XTAP_TAPCELL_ROW_108_1692 VDD VSS gf180mcu_fd_sc_mcu7t5v0__filltie
XTAP_TAPCELL_ROW_39_797 VDD VSS gf180mcu_fd_sc_mcu7t5v0__filltie
XFILLER_51_282 VDD VDD VSS VSS gf180mcu_fd_sc_mcu7t5v0__fillcap_8
XFILLER_12_658 VDD VDD VSS VSS gf180mcu_fd_sc_mcu7t5v0__fillcap_4
XTAP_TAPCELL_ROW_50_940 VDD VSS gf180mcu_fd_sc_mcu7t5v0__filltie
XTAP_TAPCELL_ROW_59_1057 VDD VSS gf180mcu_fd_sc_mcu7t5v0__filltie
XFILLER_3_323 VDD VDD VSS VSS gf180mcu_fd_sc_mcu7t5v0__fillcap_16
XTAP_TAPCELL_ROW_72_1224 VDD VSS gf180mcu_fd_sc_mcu7t5v0__filltie
XFILLER_0_2 VDD VDD VSS VSS gf180mcu_fd_sc_mcu7t5v0__fillcap_4
XFILLER_120_287 VDD VDD VSS VSS gf180mcu_fd_sc_mcu7t5v0__fillcap_4
XFILLER_47_511 VDD VDD VSS VSS gf180mcu_fd_sc_mcu7t5v0__fillcap_32
XFILLER_75_842 VDD VDD VSS VSS gf180mcu_fd_sc_mcu7t5v0__fillcap_64
XFILLER_47_50 VDD VDD VSS VSS gf180mcu_fd_sc_mcu7t5v0__fillcap_16
XFILLER_47_72 VDD VDD VSS VSS gf180mcu_fd_sc_mcu7t5v0__fillcap_4
XFILLER_90_801 VDD VDD VSS VSS gf180mcu_fd_sc_mcu7t5v0__fillcap_4
XFILLER_47_566 VDD VDD VSS VSS gf180mcu_fd_sc_mcu7t5v0__fill_2
XFILLER_90_856 VDD VDD VSS VSS gf180mcu_fd_sc_mcu7t5v0__fillcap_16
XTAP_TAPCELL_ROW_83_1364 VDD VSS gf180mcu_fd_sc_mcu7t5v0__filltie
XFILLER_31_912 VDD VDD VSS VSS gf180mcu_fd_sc_mcu7t5v0__fillcap_16
XFILLER_43_772 VDD VDD VSS VSS gf180mcu_fd_sc_mcu7t5v0__fillcap_64
Xclkbuf_3_4__f_clk clkbuf_0_clk/Z clkload3/I VDD VDD VSS VSS gf180mcu_fd_sc_mcu7t5v0__clkbuf_16
X_1840_ _4145_/Q _4144_/Q _2089_/A1 VDD VDD VSS VSS gf180mcu_fd_sc_mcu7t5v0__nand2_1
X_3510_ _4112_/Q _3510_/A2 _4112_/D VDD VDD VSS VSS gf180mcu_fd_sc_mcu7t5v0__xor2_1
XFILLER_128_387 VDD VDD VSS VSS gf180mcu_fd_sc_mcu7t5v0__fillcap_16
XFILLER_116_527 VDD VDD VSS VSS gf180mcu_fd_sc_mcu7t5v0__fillcap_64
X_3441_ _4100_/Q _3441_/A2 _3441_/B _4100_/D VDD VDD VSS VSS gf180mcu_fd_sc_mcu7t5v0__aoi21_2
XFILLER_131_508 VDD VDD VSS VSS gf180mcu_fd_sc_mcu7t5v0__fillcap_4
X_3372_ _1968_/I _3375_/A2 _3375_/A3 _3372_/Z VDD VDD VSS VSS gf180mcu_fd_sc_mcu7t5v0__and3_1
XFILLER_97_422 VDD VDD VSS VSS gf180mcu_fd_sc_mcu7t5v0__fillcap_16
X_2323_ _3413_/A1 _4098_/Q _2523_/A3 _2338_/S VDD VDD VSS VSS gf180mcu_fd_sc_mcu7t5v0__nand3_2
XFILLER_33_2 VDD VDD VSS VSS gf180mcu_fd_sc_mcu7t5v0__fillcap_64
XFILLER_85_617 VDD VDD VSS VSS gf180mcu_fd_sc_mcu7t5v0__fillcap_8
X_2254_ _3954_/Q place63/Z place67/Z _3979_/Q _3922_/Q place72/Z _2255_/I VDD VDD
+ VSS VSS gf180mcu_fd_sc_mcu7t5v0__aoi222_1
XFILLER_111_276 VDD VDD VSS VSS gf180mcu_fd_sc_mcu7t5v0__fillcap_4
X_2185_ _2185_/A1 _3065_/A1 _2185_/B _2219_/B _2186_/C VDD VDD VSS VSS gf180mcu_fd_sc_mcu7t5v0__aoi211_1
XFILLER_65_352 VDD VDD VSS VSS gf180mcu_fd_sc_mcu7t5v0__fillcap_64
XFILLER_53_547 VDD VDD VSS VSS gf180mcu_fd_sc_mcu7t5v0__fill_1
XTAP_TAPCELL_ROW_36_756 VDD VSS gf180mcu_fd_sc_mcu7t5v0__filltie
XFILLER_21_422 VDD VDD VSS VSS gf180mcu_fd_sc_mcu7t5v0__fillcap_8
XTAP_TAPCELL_ROW_16_491 VDD VSS gf180mcu_fd_sc_mcu7t5v0__filltie
XFILLER_33_282 VDD VDD VSS VSS gf180mcu_fd_sc_mcu7t5v0__fillcap_8
X_1969_ _1969_/A1 _4128_/Q _4060_/Q _4128_/D VDD VDD VSS VSS gf180mcu_fd_sc_mcu7t5v0__nor3_1
XFILLER_119_343 VDD VDD VSS VSS gf180mcu_fd_sc_mcu7t5v0__fillcap_4
X_3708_ _3708_/D _3732_/CLK _3708_/Q VDD VDD VSS VSS gf180mcu_fd_sc_mcu7t5v0__dffq_1
X_3639_ _3639_/D _3755_/CLK _3639_/Q VDD VDD VSS VSS gf180mcu_fd_sc_mcu7t5v0__dffq_1
XFILLER_89_912 VDD VDD VSS VSS gf180mcu_fd_sc_mcu7t5v0__fillcap_16
XFILLER_130_530 VDD VDD VSS VSS gf180mcu_fd_sc_mcu7t5v0__fillcap_16
XFILLER_1_838 VDD VDD VSS VSS gf180mcu_fd_sc_mcu7t5v0__fill_2
XFILLER_68_27 VDD VDD VSS VSS gf180mcu_fd_sc_mcu7t5v0__fillcap_8
XFILLER_103_766 VDD VDD VSS VSS gf180mcu_fd_sc_mcu7t5v0__fillcap_4
XFILLER_130_585 VDD VDD VSS VSS gf180mcu_fd_sc_mcu7t5v0__fillcap_8
XFILLER_124_33 VDD VDD VSS VSS gf180mcu_fd_sc_mcu7t5v0__fill_2
XFILLER_84_37 VDD VDD VSS VSS gf180mcu_fd_sc_mcu7t5v0__fillcap_32
XFILLER_57_842 VDD VDD VSS VSS gf180mcu_fd_sc_mcu7t5v0__fillcap_16
XFILLER_72_823 VDD VDD VSS VSS gf180mcu_fd_sc_mcu7t5v0__fillcap_8
XFILLER_72_801 VDD VDD VSS VSS gf180mcu_fd_sc_mcu7t5v0__fillcap_4
XFILLER_29_588 VDD VDD VSS VSS gf180mcu_fd_sc_mcu7t5v0__fillcap_8
XFILLER_71_322 VDD VDD VSS VSS gf180mcu_fd_sc_mcu7t5v0__fillcap_4
XFILLER_25_772 VDD VDD VSS VSS gf180mcu_fd_sc_mcu7t5v0__fillcap_32
XFILLER_40_731 VDD VDD VSS VSS gf180mcu_fd_sc_mcu7t5v0__fillcap_4
XFILLER_125_346 VDD VDD VSS VSS gf180mcu_fd_sc_mcu7t5v0__fillcap_4
XFILLER_125_368 VDD VDD VSS VSS gf180mcu_fd_sc_mcu7t5v0__fillcap_8
XFILLER_79_400 VDD VDD VSS VSS gf180mcu_fd_sc_mcu7t5v0__fillcap_8
XFILLER_3_131 VDD VDD VSS VSS gf180mcu_fd_sc_mcu7t5v0__fillcap_8
XFILLER_3_142 VDD VDD VSS VSS gf180mcu_fd_sc_mcu7t5v0__fillcap_64
XFILLER_79_422 VDD VDD VSS VSS gf180mcu_fd_sc_mcu7t5v0__fillcap_16
XFILLER_79_444 VDD VDD VSS VSS gf180mcu_fd_sc_mcu7t5v0__fill_1
XFILLER_121_585 VDD VDD VSS VSS gf180mcu_fd_sc_mcu7t5v0__fillcap_8
XFILLER_94_403 VDD VDD VSS VSS gf180mcu_fd_sc_mcu7t5v0__fill_1
XFILLER_75_650 VDD VDD VSS VSS gf180mcu_fd_sc_mcu7t5v0__fillcap_16
XFILLER_47_352 VDD VDD VSS VSS gf180mcu_fd_sc_mcu7t5v0__fillcap_64
XFILLER_48_897 VDD VDD VSS VSS gf180mcu_fd_sc_mcu7t5v0__fill_1
XFILLER_74_160 VDD VDD VSS VSS gf180mcu_fd_sc_mcu7t5v0__fillcap_8
X_3990_ _3990_/D input92/Z _4023_/CLK _3990_/Q VDD VDD VSS VSS gf180mcu_fd_sc_mcu7t5v0__dffrnq_1
X_2941_ _4037_/Q _3917_/Q _2972_/S _3917_/D VDD VDD VSS VSS gf180mcu_fd_sc_mcu7t5v0__mux2_2
XTAP_TAPCELL_ROW_33_715 VDD VSS gf180mcu_fd_sc_mcu7t5v0__filltie
XFILLER_15_282 VDD VDD VSS VSS gf180mcu_fd_sc_mcu7t5v0__fillcap_8
XTAP_TAPCELL_ROW_13_450 VDD VSS gf180mcu_fd_sc_mcu7t5v0__filltie
XFILLER_30_241 VDD VDD VSS VSS gf180mcu_fd_sc_mcu7t5v0__fillcap_4
X_1823_ _1819_/Z _1820_/Z _1822_/Z _1948_/C VDD VDD VSS VSS gf180mcu_fd_sc_mcu7t5v0__nor3_4
XTAP_TAPCELL_ROW_13_461 VDD VSS gf180mcu_fd_sc_mcu7t5v0__filltie
XTAP_TAPCELL_ROW_96_1533 VDD VSS gf180mcu_fd_sc_mcu7t5v0__filltie
XFILLER_128_195 VDD VDD VSS VSS gf180mcu_fd_sc_mcu7t5v0__fill_1
XFILLER_7_492 VDD VDD VSS VSS gf180mcu_fd_sc_mcu7t5v0__fillcap_32
XFILLER_7_470 VDD VDD VSS VSS gf180mcu_fd_sc_mcu7t5v0__fillcap_4
X_3424_ _4102_/Q _3449_/C VDD VDD VSS VSS gf180mcu_fd_sc_mcu7t5v0__clkinv_1
XPHY_EDGE_ROW_115_Right_115 VDD VSS gf180mcu_fd_sc_mcu7t5v0__endcap
X_3355_ _3902_/Q _3355_/A2 _4080_/D VDD VDD VSS VSS gf180mcu_fd_sc_mcu7t5v0__and2_1
XFILLER_112_574 VDD VDD VSS VSS gf180mcu_fd_sc_mcu7t5v0__fillcap_4
XFILLER_98_797 VDD VDD VSS VSS gf180mcu_fd_sc_mcu7t5v0__fillcap_8
XFILLER_98_786 VDD VDD VSS VSS gf180mcu_fd_sc_mcu7t5v0__fill_2
X_3286_ _3904_/Q place91/Z _4166_/Q _3287_/A3 VDD VDD VSS VSS gf180mcu_fd_sc_mcu7t5v0__oai21_1
XFILLER_39_842 VDD VDD VSS VSS gf180mcu_fd_sc_mcu7t5v0__fillcap_64
XFILLER_38_341 VDD VDD VSS VSS gf180mcu_fd_sc_mcu7t5v0__fill_2
X_2168_ _2181_/A3 _2168_/A2 _2169_/C VDD VDD VSS VSS gf180mcu_fd_sc_mcu7t5v0__nor2_1
X_2099_ _2008_/Z _2099_/A2 _2099_/B _4147_/D VDD VDD VSS VSS gf180mcu_fd_sc_mcu7t5v0__oai21_4
XFILLER_81_664 VDD VDD VSS VSS gf180mcu_fd_sc_mcu7t5v0__fillcap_32
XTAP_TAPCELL_ROW_105_1651 VDD VSS gf180mcu_fd_sc_mcu7t5v0__filltie
XFILLER_80_174 VDD VDD VSS VSS gf180mcu_fd_sc_mcu7t5v0__fill_1
XFILLER_13_208 VDD VDD VSS VSS gf180mcu_fd_sc_mcu7t5v0__fill_2
XFILLER_21_230 VDD VDD VSS VSS gf180mcu_fd_sc_mcu7t5v0__fillcap_8
XPHY_EDGE_ROW_17_Right_17 VDD VSS gf180mcu_fd_sc_mcu7t5v0__endcap
XFILLER_5_418 VDD VDD VSS VSS gf180mcu_fd_sc_mcu7t5v0__fill_2
XFILLER_108_869 VDD VDD VSS VSS gf180mcu_fd_sc_mcu7t5v0__fillcap_4
XTAP_TAPCELL_ROW_56_1016 VDD VSS gf180mcu_fd_sc_mcu7t5v0__filltie
XFILLER_116_891 VDD VDD VSS VSS gf180mcu_fd_sc_mcu7t5v0__fill_1
XTAP_TAPCELL_ROW_116_1791 VDD VSS gf180mcu_fd_sc_mcu7t5v0__filltie
XFILLER_89_720 VDD VDD VSS VSS gf180mcu_fd_sc_mcu7t5v0__fill_1
XFILLER_89_753 VDD VDD VSS VSS gf180mcu_fd_sc_mcu7t5v0__fillcap_16
XPHY_EDGE_ROW_26_Right_26 VDD VSS gf180mcu_fd_sc_mcu7t5v0__endcap
XFILLER_95_69 VDD VDD VSS VSS gf180mcu_fd_sc_mcu7t5v0__fill_1
XFILLER_28_41 VDD VDD VSS VSS gf180mcu_fd_sc_mcu7t5v0__fill_2
XFILLER_28_74 VDD VDD VSS VSS gf180mcu_fd_sc_mcu7t5v0__fillcap_16
XFILLER_56_171 VDD VDD VSS VSS gf180mcu_fd_sc_mcu7t5v0__fillcap_4
XTAP_TAPCELL_ROW_67_1156 VDD VSS gf180mcu_fd_sc_mcu7t5v0__filltie
XTAP_TAPCELL_ROW_80_1323 VDD VSS gf180mcu_fd_sc_mcu7t5v0__filltie
XFILLER_13_742 VDD VDD VSS VSS gf180mcu_fd_sc_mcu7t5v0__fillcap_16
XPHY_EDGE_ROW_35_Right_35 VDD VSS gf180mcu_fd_sc_mcu7t5v0__endcap
XFILLER_40_583 VDD VDD VSS VSS gf180mcu_fd_sc_mcu7t5v0__fillcap_8
XTAP_TAPCELL_ROW_10_420 VDD VSS gf180mcu_fd_sc_mcu7t5v0__filltie
XTAP_TAPCELL_ROW_78_1296 VDD VSS gf180mcu_fd_sc_mcu7t5v0__filltie
XFILLER_4_473 VDD VDD VSS VSS gf180mcu_fd_sc_mcu7t5v0__fill_2
XFILLER_113_349 VDD VDD VSS VSS gf180mcu_fd_sc_mcu7t5v0__fill_1
XTAP_TAPCELL_ROW_91_1474 VDD VSS gf180mcu_fd_sc_mcu7t5v0__filltie
XTAP_TAPCELL_ROW_91_1463 VDD VSS gf180mcu_fd_sc_mcu7t5v0__filltie
XPHY_EDGE_ROW_44_Right_44 VDD VSS gf180mcu_fd_sc_mcu7t5v0__endcap
XFILLER_122_883 VDD VDD VSS VSS gf180mcu_fd_sc_mcu7t5v0__fill_1
X_3140_ _4010_/Q _3140_/I1 _3160_/S _4010_/D VDD VDD VSS VSS gf180mcu_fd_sc_mcu7t5v0__mux2_2
XPHY_EDGE_ROW_105_Left_238 VDD VSS gf180mcu_fd_sc_mcu7t5v0__endcap
X_3071_ _4039_/Q _3976_/Q _3081_/S _3976_/D VDD VDD VSS VSS gf180mcu_fd_sc_mcu7t5v0__mux2_2
XFILLER_48_661 VDD VDD VSS VSS gf180mcu_fd_sc_mcu7t5v0__fillcap_4
X_2022_ _2008_/Z _2022_/A2 _2022_/B _4133_/D VDD VDD VSS VSS gf180mcu_fd_sc_mcu7t5v0__oai21_4
XFILLER_36_823 VDD VDD VSS VSS gf180mcu_fd_sc_mcu7t5v0__fillcap_4
XTAP_TAPCELL_ROW_18_520 VDD VSS gf180mcu_fd_sc_mcu7t5v0__filltie
XFILLER_63_653 VDD VDD VSS VSS gf180mcu_fd_sc_mcu7t5v0__fillcap_16
XTAP_TAPCELL_ROW_46_884 VDD VSS gf180mcu_fd_sc_mcu7t5v0__filltie
XFILLER_62_174 VDD VDD VSS VSS gf180mcu_fd_sc_mcu7t5v0__fill_1
XFILLER_16_591 VDD VDD VSS VSS gf180mcu_fd_sc_mcu7t5v0__fillcap_4
XPHY_EDGE_ROW_53_Right_53 VDD VSS gf180mcu_fd_sc_mcu7t5v0__endcap
X_3973_ _3973_/D _2279_/I _4112_/CLK _3973_/Q VDD VDD VSS VSS gf180mcu_fd_sc_mcu7t5v0__dffrnq_1
XPHY_EDGE_ROW_114_Left_247 VDD VSS gf180mcu_fd_sc_mcu7t5v0__endcap
X_2924_ _4029_/Q _3909_/Q _2972_/S _3909_/D VDD VDD VSS VSS gf180mcu_fd_sc_mcu7t5v0__mux2_2
X_2855_ place89/Z _3878_/Q _2867_/S _3878_/D VDD VDD VSS VSS gf180mcu_fd_sc_mcu7t5v0__mux2_2
X_1806_ _2013_/A1 _1803_/Z _2013_/A3 _2013_/A4 place71/I VDD VDD VSS VSS gf180mcu_fd_sc_mcu7t5v0__nand4_1
XTAP_TAPCELL_ROW_100_1592 VDD VSS gf180mcu_fd_sc_mcu7t5v0__filltie
XTAP_TAPCELL_ROW_100_1581 VDD VSS gf180mcu_fd_sc_mcu7t5v0__filltie
Xhold201 s_axi_wdata[0] hold201/Z VDD VDD VSS VSS gf180mcu_fd_sc_mcu7t5v0__dlyc_1
Xhold223 s_axi_rready hold223/Z VDD VDD VSS VSS gf180mcu_fd_sc_mcu7t5v0__dlyc_1
XFILLER_117_688 VDD VDD VSS VSS gf180mcu_fd_sc_mcu7t5v0__fillcap_8
XFILLER_105_828 VDD VDD VSS VSS gf180mcu_fd_sc_mcu7t5v0__fillcap_8
Xhold212 s_axi_wdata[17] hold212/Z VDD VDD VSS VSS gf180mcu_fd_sc_mcu7t5v0__dlyc_1
XFILLER_116_165 VDD VDD VSS VSS gf180mcu_fd_sc_mcu7t5v0__fillcap_8
XPHY_EDGE_ROW_62_Right_62 VDD VSS gf180mcu_fd_sc_mcu7t5v0__endcap
XFILLER_131_135 VDD VDD VSS VSS gf180mcu_fd_sc_mcu7t5v0__fillcap_4
XPHY_EDGE_ROW_123_Left_256 VDD VSS gf180mcu_fd_sc_mcu7t5v0__endcap
X_3407_ _4095_/Q _3407_/A2 _4095_/D VDD VDD VSS VSS gf180mcu_fd_sc_mcu7t5v0__xor2_1
XFILLER_86_701 VDD VDD VSS VSS gf180mcu_fd_sc_mcu7t5v0__fill_1
X_3338_ _3338_/A1 _3319_/B _3339_/B VDD VDD VSS VSS gf180mcu_fd_sc_mcu7t5v0__nand2_1
XFILLER_58_436 VDD VDD VSS VSS gf180mcu_fd_sc_mcu7t5v0__fillcap_16
X_3269_ _4062_/Q _3263_/Z _3270_/A2 VDD VDD VSS VSS gf180mcu_fd_sc_mcu7t5v0__nor2_1
XFILLER_26_311 VDD VDD VSS VSS gf180mcu_fd_sc_mcu7t5v0__fillcap_4
XFILLER_27_856 VDD VDD VSS VSS gf180mcu_fd_sc_mcu7t5v0__fill_1
XFILLER_54_664 VDD VDD VSS VSS gf180mcu_fd_sc_mcu7t5v0__fill_1
XPHY_EDGE_ROW_132_Left_265 VDD VSS gf180mcu_fd_sc_mcu7t5v0__endcap
XPHY_EDGE_ROW_71_Right_71 VDD VSS gf180mcu_fd_sc_mcu7t5v0__endcap
XFILLER_14_10 VDD VDD VSS VSS gf180mcu_fd_sc_mcu7t5v0__fill_2
XFILLER_10_734 VDD VDD VSS VSS gf180mcu_fd_sc_mcu7t5v0__fill_1
XTAP_TAPCELL_ROW_62_1086 VDD VSS gf180mcu_fd_sc_mcu7t5v0__filltie
XTAP_TAPCELL_ROW_62_1097 VDD VSS gf180mcu_fd_sc_mcu7t5v0__filltie
XTAP_TAPCELL_ROW_118_1820 VDD VSS gf180mcu_fd_sc_mcu7t5v0__filltie
XPHY_EDGE_ROW_80_Right_80 VDD VSS gf180mcu_fd_sc_mcu7t5v0__endcap
XFILLER_2_933 VDD VDD VSS VSS gf180mcu_fd_sc_mcu7t5v0__fill_1
XFILLER_77_734 VDD VDD VSS VSS gf180mcu_fd_sc_mcu7t5v0__fillcap_4
XTAP_TAPCELL_ROW_129_1960 VDD VSS gf180mcu_fd_sc_mcu7t5v0__filltie
XFILLER_92_737 VDD VDD VSS VSS gf180mcu_fd_sc_mcu7t5v0__fillcap_32
XFILLER_91_258 VDD VDD VSS VSS gf180mcu_fd_sc_mcu7t5v0__fillcap_8
XFILLER_55_61 VDD VDD VSS VSS gf180mcu_fd_sc_mcu7t5v0__fillcap_8
XFILLER_55_72 VDD VDD VSS VSS gf180mcu_fd_sc_mcu7t5v0__fillcap_64
XFILLER_32_314 VDD VDD VSS VSS gf180mcu_fd_sc_mcu7t5v0__fill_1
XTAP_TAPCELL_ROW_43_843 VDD VSS gf180mcu_fd_sc_mcu7t5v0__filltie
XFILLER_60_667 VDD VDD VSS VSS gf180mcu_fd_sc_mcu7t5v0__fillcap_32
XFILLER_119_909 VDD VDD VSS VSS gf180mcu_fd_sc_mcu7t5v0__fill_1
XFILLER_9_532 VDD VDD VSS VSS gf180mcu_fd_sc_mcu7t5v0__fill_2
X_2640_ _4120_/Q _4121_/Q _2835_/A1 VDD VDD VSS VSS gf180mcu_fd_sc_mcu7t5v0__nor2_1
XFILLER_114_614 VDD VDD VSS VSS gf180mcu_fd_sc_mcu7t5v0__fillcap_32
X_3123_ _4002_/Q _3123_/I1 _3160_/S _4002_/D VDD VDD VSS VSS gf180mcu_fd_sc_mcu7t5v0__mux2_2
XFILLER_68_767 VDD VDD VSS VSS gf180mcu_fd_sc_mcu7t5v0__fill_1
X_3054_ _4049_/Q _3969_/Q _3081_/S _3969_/D VDD VDD VSS VSS gf180mcu_fd_sc_mcu7t5v0__mux2_2
XFILLER_82_225 VDD VDD VSS VSS gf180mcu_fd_sc_mcu7t5v0__fillcap_4
XFILLER_67_277 VDD VDD VSS VSS gf180mcu_fd_sc_mcu7t5v0__fill_2
XFILLER_82_247 VDD VDD VSS VSS gf180mcu_fd_sc_mcu7t5v0__fillcap_64
X_2005_ place88/Z _2007_/A2 _2005_/B _4126_/D VDD VDD VSS VSS gf180mcu_fd_sc_mcu7t5v0__aoi21_1
XTAP_TAPCELL_ROW_102_1610 VDD VSS gf180mcu_fd_sc_mcu7t5v0__filltie
XFILLER_90_291 VDD VDD VSS VSS gf180mcu_fd_sc_mcu7t5v0__fillcap_16
X_3956_ _3956_/D _2279_/I _3981_/CLK _3956_/Q VDD VDD VSS VSS gf180mcu_fd_sc_mcu7t5v0__dffrnq_1
XFILLER_50_177 VDD VDD VSS VSS gf180mcu_fd_sc_mcu7t5v0__fillcap_64
X_3887_ _3887_/D _4148_/RN _4138_/CLK _3887_/Q VDD VDD VSS VSS gf180mcu_fd_sc_mcu7t5v0__dffrnq_1
XTAP_TAPCELL_ROW_21_559 VDD VSS gf180mcu_fd_sc_mcu7t5v0__filltie
X_2838_ place89/Z _3870_/Q _2850_/S _3870_/D VDD VDD VSS VSS gf180mcu_fd_sc_mcu7t5v0__mux2_2
XFILLER_117_430 VDD VDD VSS VSS gf180mcu_fd_sc_mcu7t5v0__fillcap_4
XFILLER_117_474 VDD VDD VSS VSS gf180mcu_fd_sc_mcu7t5v0__fill_1
XFILLER_105_636 VDD VDD VSS VSS gf180mcu_fd_sc_mcu7t5v0__fill_1
XFILLER_132_444 VDD VDD VSS VSS gf180mcu_fd_sc_mcu7t5v0__fillcap_8
XTAP_TAPCELL_ROW_113_1750 VDD VSS gf180mcu_fd_sc_mcu7t5v0__filltie
XTAP_TAPCELL_ROW_113_1761 VDD VSS gf180mcu_fd_sc_mcu7t5v0__filltie
XFILLER_101_842 VDD VDD VSS VSS gf180mcu_fd_sc_mcu7t5v0__fillcap_8
XFILLER_76_27 VDD VDD VSS VSS gf180mcu_fd_sc_mcu7t5v0__fillcap_8
XFILLER_132_33 VDD VDD VSS VSS gf180mcu_fd_sc_mcu7t5v0__fill_1
XFILLER_86_597 VDD VDD VSS VSS gf180mcu_fd_sc_mcu7t5v0__fillcap_16
Xplace48 place48/I _2574_/S VDD VDD VSS VSS gf180mcu_fd_sc_mcu7t5v0__buf_8
Xplace59 place59/I _2395_/S VDD VDD VSS VSS gf180mcu_fd_sc_mcu7t5v0__buf_8
XTAP_TAPCELL_ROW_29_659 VDD VSS gf180mcu_fd_sc_mcu7t5v0__filltie
XFILLER_132_99 VDD VDD VSS VSS gf180mcu_fd_sc_mcu7t5v0__fill_2
XFILLER_92_37 VDD VDD VSS VSS gf180mcu_fd_sc_mcu7t5v0__fillcap_16
XFILLER_15_837 VDD VDD VSS VSS gf180mcu_fd_sc_mcu7t5v0__fill_2
XFILLER_27_697 VDD VDD VSS VSS gf180mcu_fd_sc_mcu7t5v0__fill_2
XTAP_TAPCELL_ROW_64_1115 VDD VSS gf180mcu_fd_sc_mcu7t5v0__filltie
XTAP_TAPCELL_ROW_1_295 VDD VSS gf180mcu_fd_sc_mcu7t5v0__filltie
XFILLER_26_174 VDD VDD VSS VSS gf180mcu_fd_sc_mcu7t5v0__fill_1
XFILLER_42_656 VDD VDD VSS VSS gf180mcu_fd_sc_mcu7t5v0__fillcap_8
XFILLER_54_483 VDD VDD VSS VSS gf180mcu_fd_sc_mcu7t5v0__fillcap_8
XFILLER_30_807 VDD VDD VSS VSS gf180mcu_fd_sc_mcu7t5v0__fillcap_16
XTAP_TAPCELL_ROW_40_802 VDD VSS gf180mcu_fd_sc_mcu7t5v0__filltie
XFILLER_42_667 VDD VDD VSS VSS gf180mcu_fd_sc_mcu7t5v0__fill_2
XFILLER_128_728 VDD VDD VSS VSS gf180mcu_fd_sc_mcu7t5v0__fillcap_4
XFILLER_10_553 VDD VDD VSS VSS gf180mcu_fd_sc_mcu7t5v0__fillcap_32
XFILLER_22_391 VDD VDD VSS VSS gf180mcu_fd_sc_mcu7t5v0__fill_2
XFILLER_127_227 VDD VDD VSS VSS gf180mcu_fd_sc_mcu7t5v0__fillcap_32
XFILLER_6_535 VDD VDD VSS VSS gf180mcu_fd_sc_mcu7t5v0__fillcap_4
XFILLER_6_524 VDD VDD VSS VSS gf180mcu_fd_sc_mcu7t5v0__fill_1
XFILLER_10_597 VDD VDD VSS VSS gf180mcu_fd_sc_mcu7t5v0__fillcap_32
XFILLER_123_422 VDD VDD VSS VSS gf180mcu_fd_sc_mcu7t5v0__fillcap_64
XTAP_TAPCELL_ROW_75_1266 VDD VSS gf180mcu_fd_sc_mcu7t5v0__filltie
XTAP_TAPCELL_ROW_75_1255 VDD VSS gf180mcu_fd_sc_mcu7t5v0__filltie
XFILLER_2_730 VDD VDD VSS VSS gf180mcu_fd_sc_mcu7t5v0__fillcap_4
XFILLER_96_317 VDD VDD VSS VSS gf180mcu_fd_sc_mcu7t5v0__fillcap_16
XFILLER_96_306 VDD VDD VSS VSS gf180mcu_fd_sc_mcu7t5v0__fillcap_8
XFILLER_110_149 VDD VDD VSS VSS gf180mcu_fd_sc_mcu7t5v0__fill_1
XFILLER_103_190 VDD VDD VSS VSS gf180mcu_fd_sc_mcu7t5v0__fillcap_4
XFILLER_92_534 VDD VDD VSS VSS gf180mcu_fd_sc_mcu7t5v0__fill_1
XTAP_TAPCELL_ROW_48_913 VDD VSS gf180mcu_fd_sc_mcu7t5v0__filltie
XFILLER_80_707 VDD VDD VSS VSS gf180mcu_fd_sc_mcu7t5v0__fillcap_4
XFILLER_64_247 VDD VDD VSS VSS gf180mcu_fd_sc_mcu7t5v0__fillcap_64
XFILLER_45_461 VDD VDD VSS VSS gf180mcu_fd_sc_mcu7t5v0__fillcap_8
XFILLER_32_122 VDD VDD VSS VSS gf180mcu_fd_sc_mcu7t5v0__fillcap_32
X_3810_ _3810_/D clkload8/I _3810_/Q VDD VDD VSS VSS gf180mcu_fd_sc_mcu7t5v0__dffq_1
X_3741_ _3741_/D _3749_/CLK _3741_/Q VDD VDD VSS VSS gf180mcu_fd_sc_mcu7t5v0__dffq_1
XFILLER_32_177 VDD VDD VSS VSS gf180mcu_fd_sc_mcu7t5v0__fillcap_64
X_3672_ _3672_/D _4108_/CLK _3672_/Q VDD VDD VSS VSS gf180mcu_fd_sc_mcu7t5v0__dffq_1
X_2623_ _2852_/A1 _3542_/A3 _2638_/S VDD VDD VSS VSS gf180mcu_fd_sc_mcu7t5v0__nand2_2
XFILLER_127_772 VDD VDD VSS VSS gf180mcu_fd_sc_mcu7t5v0__fillcap_4
XFILLER_115_912 VDD VDD VSS VSS gf180mcu_fd_sc_mcu7t5v0__fillcap_16
X_2554_ _3747_/Q _4073_/Q _2556_/S _3747_/D VDD VDD VSS VSS gf180mcu_fd_sc_mcu7t5v0__mux2_2
Xoutput147 _2124_/ZN s_axi_rdata[0] VDD VDD VSS VSS gf180mcu_fd_sc_mcu7t5v0__dlyb_1
Xoutput158 _2142_/ZN s_axi_rdata[1] VDD VDD VSS VSS gf180mcu_fd_sc_mcu7t5v0__dlyb_1
XFILLER_126_293 VDD VDD VSS VSS gf180mcu_fd_sc_mcu7t5v0__fillcap_8
XFILLER_88_807 VDD VDD VSS VSS gf180mcu_fd_sc_mcu7t5v0__fillcap_4
Xoutput169 _2156_/ZN s_axi_rdata[2] VDD VDD VSS VSS gf180mcu_fd_sc_mcu7t5v0__dlyb_1
XFILLER_130_926 VDD VDD VSS VSS gf180mcu_fd_sc_mcu7t5v0__fillcap_8
X_2485_ _3716_/Q _4074_/Q _2485_/S _3716_/D VDD VDD VSS VSS gf180mcu_fd_sc_mcu7t5v0__mux2_2
XFILLER_68_520 VDD VDD VSS VSS gf180mcu_fd_sc_mcu7t5v0__fillcap_4
XFILLER_110_661 VDD VDD VSS VSS gf180mcu_fd_sc_mcu7t5v0__fillcap_4
X_4155_ _4155_/D _4157_/RN _4156_/CLK _4155_/Q VDD VDD VSS VSS gf180mcu_fd_sc_mcu7t5v0__dffrnq_1
XFILLER_56_737 VDD VDD VSS VSS gf180mcu_fd_sc_mcu7t5v0__fillcap_8
XFILLER_68_597 VDD VDD VSS VSS gf180mcu_fd_sc_mcu7t5v0__fillcap_32
X_3106_ _3994_/Q _3106_/I1 _3160_/S _3994_/D VDD VDD VSS VSS gf180mcu_fd_sc_mcu7t5v0__mux2_2
X_4086_ _4086_/D _2279_/I _4092_/CLK _4086_/Q VDD VDD VSS VSS gf180mcu_fd_sc_mcu7t5v0__dffrnq_1
X_3037_ _3962_/Q _4050_/Q _3041_/S _3962_/D VDD VDD VSS VSS gf180mcu_fd_sc_mcu7t5v0__mux2_2
XTAP_TAPCELL_ROW_26_618 VDD VSS gf180mcu_fd_sc_mcu7t5v0__filltie
XTAP_TAPCELL_ROW_26_629 VDD VSS gf180mcu_fd_sc_mcu7t5v0__filltie
XFILLER_52_921 VDD VDD VSS VSS gf180mcu_fd_sc_mcu7t5v0__fillcap_8
XFILLER_24_634 VDD VDD VSS VSS gf180mcu_fd_sc_mcu7t5v0__fillcap_16
XFILLER_70_239 VDD VDD VSS VSS gf180mcu_fd_sc_mcu7t5v0__fillcap_4
XFILLER_12_807 VDD VDD VSS VSS gf180mcu_fd_sc_mcu7t5v0__fillcap_8
XFILLER_24_667 VDD VDD VSS VSS gf180mcu_fd_sc_mcu7t5v0__fillcap_64
X_3939_ _3939_/D _2279_/I _4126_/CLK _3939_/Q VDD VDD VSS VSS gf180mcu_fd_sc_mcu7t5v0__dffrnq_1
XFILLER_118_772 VDD VDD VSS VSS gf180mcu_fd_sc_mcu7t5v0__fillcap_16
XFILLER_11_66 VDD VDD VSS VSS gf180mcu_fd_sc_mcu7t5v0__fillcap_4
XFILLER_117_282 VDD VDD VSS VSS gf180mcu_fd_sc_mcu7t5v0__fillcap_8
XFILLER_105_422 VDD VDD VSS VSS gf180mcu_fd_sc_mcu7t5v0__fillcap_16
XFILLER_127_88 VDD VDD VSS VSS gf180mcu_fd_sc_mcu7t5v0__fillcap_32
XFILLER_120_403 VDD VDD VSS VSS gf180mcu_fd_sc_mcu7t5v0__fill_2
XFILLER_78_317 VDD VDD VSS VSS gf180mcu_fd_sc_mcu7t5v0__fillcap_64
XFILLER_132_274 VDD VDD VSS VSS gf180mcu_fd_sc_mcu7t5v0__fillcap_32
XFILLER_59_531 VDD VDD VSS VSS gf180mcu_fd_sc_mcu7t5v0__fillcap_16
XTAP_TAPCELL_ROW_6_365 VDD VSS gf180mcu_fd_sc_mcu7t5v0__filltie
XFILLER_46_214 VDD VDD VSS VSS gf180mcu_fd_sc_mcu7t5v0__fill_1
XFILLER_47_726 VDD VDD VSS VSS gf180mcu_fd_sc_mcu7t5v0__fill_2
XTAP_TAPCELL_ROW_70_1196 VDD VSS gf180mcu_fd_sc_mcu7t5v0__filltie
XTAP_TAPCELL_ROW_126_1930 VDD VSS gf180mcu_fd_sc_mcu7t5v0__filltie
XFILLER_74_567 VDD VDD VSS VSS gf180mcu_fd_sc_mcu7t5v0__fill_2
XFILLER_46_247 VDD VDD VSS VSS gf180mcu_fd_sc_mcu7t5v0__fill_2
XFILLER_61_206 VDD VDD VSS VSS gf180mcu_fd_sc_mcu7t5v0__fillcap_4
XFILLER_15_634 VDD VDD VSS VSS gf180mcu_fd_sc_mcu7t5v0__fill_1
XFILLER_43_932 VDD VDD VSS VSS gf180mcu_fd_sc_mcu7t5v0__fill_2
XFILLER_54_280 VDD VDD VSS VSS gf180mcu_fd_sc_mcu7t5v0__fillcap_32
XFILLER_61_239 VDD VDD VSS VSS gf180mcu_fd_sc_mcu7t5v0__fillcap_32
XFILLER_14_177 VDD VDD VSS VSS gf180mcu_fd_sc_mcu7t5v0__fillcap_32
XTAP_TAPCELL_ROW_53_971 VDD VSS gf180mcu_fd_sc_mcu7t5v0__filltie
XFILLER_30_648 VDD VDD VSS VSS gf180mcu_fd_sc_mcu7t5v0__fillcap_16
XFILLER_116_709 VDD VDD VSS VSS gf180mcu_fd_sc_mcu7t5v0__fillcap_16
XFILLER_109_772 VDD VDD VSS VSS gf180mcu_fd_sc_mcu7t5v0__fillcap_16
XFILLER_6_387 VDD VDD VSS VSS gf180mcu_fd_sc_mcu7t5v0__fillcap_8
XFILLER_124_731 VDD VDD VSS VSS gf180mcu_fd_sc_mcu7t5v0__fillcap_4
XFILLER_111_403 VDD VDD VSS VSS gf180mcu_fd_sc_mcu7t5v0__fillcap_16
X_2270_ _3930_/Q place72/Z place63/Z _3962_/Q _3970_/Q place67/Z _2271_/I VDD VDD
+ VSS VSS gf180mcu_fd_sc_mcu7t5v0__aoi222_1
XFILLER_96_125 VDD VDD VSS VSS gf180mcu_fd_sc_mcu7t5v0__fillcap_32
XFILLER_78_862 VDD VDD VSS VSS gf180mcu_fd_sc_mcu7t5v0__fillcap_8
XTAP_TAPCELL_ROW_88_1424 VDD VSS gf180mcu_fd_sc_mcu7t5v0__filltie
XFILLER_38_737 VDD VDD VSS VSS gf180mcu_fd_sc_mcu7t5v0__fillcap_32
XTAP_TAPCELL_ROW_88_1435 VDD VSS gf180mcu_fd_sc_mcu7t5v0__filltie
XFILLER_93_876 VDD VDD VSS VSS gf180mcu_fd_sc_mcu7t5v0__fill_2
XFILLER_34_932 VDD VDD VSS VSS gf180mcu_fd_sc_mcu7t5v0__fill_2
XFILLER_46_792 VDD VDD VSS VSS gf180mcu_fd_sc_mcu7t5v0__fillcap_8
XFILLER_45_291 VDD VDD VSS VSS gf180mcu_fd_sc_mcu7t5v0__fillcap_32
XFILLER_21_626 VDD VDD VSS VSS gf180mcu_fd_sc_mcu7t5v0__fillcap_4
XFILLER_33_486 VDD VDD VSS VSS gf180mcu_fd_sc_mcu7t5v0__fillcap_4
X_1985_ _4085_/Q _1986_/C VDD VDD VSS VSS gf180mcu_fd_sc_mcu7t5v0__clkinv_1
XFILLER_20_136 VDD VDD VSS VSS gf180mcu_fd_sc_mcu7t5v0__fillcap_32
X_3724_ _3724_/D _3732_/CLK _3724_/Q VDD VDD VSS VSS gf180mcu_fd_sc_mcu7t5v0__dffq_1
XTAP_TAPCELL_ROW_31_687 VDD VSS gf180mcu_fd_sc_mcu7t5v0__filltie
XTAP_TAPCELL_ROW_99_1575 VDD VSS gf180mcu_fd_sc_mcu7t5v0__filltie
X_3655_ _3655_/D _3750_/CLK _3655_/Q VDD VDD VSS VSS gf180mcu_fd_sc_mcu7t5v0__dffq_1
X_3586_ _3585_/Z _4154_/Q _3600_/S _4154_/D VDD VDD VSS VSS gf180mcu_fd_sc_mcu7t5v0__mux2_2
XFILLER_114_263 VDD VDD VSS VSS gf180mcu_fd_sc_mcu7t5v0__fillcap_4
XTAP_TAPCELL_ROW_110_1720 VDD VSS gf180mcu_fd_sc_mcu7t5v0__filltie
X_2468_ _4097_/Q _3414_/A1 _2505_/A2 VDD VDD VSS VSS gf180mcu_fd_sc_mcu7t5v0__nand2_1
XFILLER_57_18 VDD VDD VSS VSS gf180mcu_fd_sc_mcu7t5v0__fillcap_32
XFILLER_84_821 VDD VDD VSS VSS gf180mcu_fd_sc_mcu7t5v0__fillcap_32
XTAP_TAPCELL_ROW_3_324 VDD VSS gf180mcu_fd_sc_mcu7t5v0__filltie
XFILLER_68_383 VDD VDD VSS VSS gf180mcu_fd_sc_mcu7t5v0__fill_2
X_4138_ _4138_/D _4148_/RN _4138_/CLK _4138_/Q VDD VDD VSS VSS gf180mcu_fd_sc_mcu7t5v0__dffrnq_1
XFILLER_28_247 VDD VDD VSS VSS gf180mcu_fd_sc_mcu7t5v0__fillcap_16
XFILLER_113_68 VDD VDD VSS VSS gf180mcu_fd_sc_mcu7t5v0__fill_2
X_4069_ _4069_/D input92/Z _4166_/CLK _4069_/Q VDD VDD VSS VSS gf180mcu_fd_sc_mcu7t5v0__dffrnq_1
XTAP_TAPCELL_ROW_39_787 VDD VSS gf180mcu_fd_sc_mcu7t5v0__filltie
XFILLER_43_206 VDD VDD VSS VSS gf180mcu_fd_sc_mcu7t5v0__fillcap_4
XTAP_TAPCELL_ROW_108_1693 VDD VSS gf180mcu_fd_sc_mcu7t5v0__filltie
XFILLER_71_559 VDD VDD VSS VSS gf180mcu_fd_sc_mcu7t5v0__fill_1
XFILLER_25_932 VDD VDD VSS VSS gf180mcu_fd_sc_mcu7t5v0__fill_2
XTAP_TAPCELL_ROW_39_798 VDD VSS gf180mcu_fd_sc_mcu7t5v0__filltie
XTAP_TAPCELL_ROW_121_1860 VDD VSS gf180mcu_fd_sc_mcu7t5v0__filltie
XFILLER_40_924 VDD VDD VSS VSS gf180mcu_fd_sc_mcu7t5v0__fillcap_8
XFILLER_11_136 VDD VDD VSS VSS gf180mcu_fd_sc_mcu7t5v0__fillcap_4
XTAP_TAPCELL_ROW_50_930 VDD VSS gf180mcu_fd_sc_mcu7t5v0__filltie
XTAP_TAPCELL_ROW_50_941 VDD VSS gf180mcu_fd_sc_mcu7t5v0__filltie
XPHY_EDGE_ROW_129_Right_129 VDD VSS gf180mcu_fd_sc_mcu7t5v0__endcap
XTAP_TAPCELL_ROW_59_1047 VDD VSS gf180mcu_fd_sc_mcu7t5v0__filltie
XFILLER_118_591 VDD VDD VSS VSS gf180mcu_fd_sc_mcu7t5v0__fillcap_4
XTAP_TAPCELL_ROW_59_1058 VDD VSS gf180mcu_fd_sc_mcu7t5v0__filltie
XFILLER_106_753 VDD VDD VSS VSS gf180mcu_fd_sc_mcu7t5v0__fill_1
XTAP_TAPCELL_ROW_72_1225 VDD VSS gf180mcu_fd_sc_mcu7t5v0__filltie
XFILLER_79_626 VDD VDD VSS VSS gf180mcu_fd_sc_mcu7t5v0__fillcap_4
XFILLER_78_103 VDD VDD VSS VSS gf180mcu_fd_sc_mcu7t5v0__fill_2
XFILLER_120_244 VDD VDD VSS VSS gf180mcu_fd_sc_mcu7t5v0__fill_1
XFILLER_94_629 VDD VDD VSS VSS gf180mcu_fd_sc_mcu7t5v0__fill_2
XFILLER_75_832 VDD VDD VSS VSS gf180mcu_fd_sc_mcu7t5v0__fillcap_8
XFILLER_74_331 VDD VDD VSS VSS gf180mcu_fd_sc_mcu7t5v0__fillcap_16
XFILLER_90_824 VDD VDD VSS VSS gf180mcu_fd_sc_mcu7t5v0__fillcap_32
XFILLER_28_770 VDD VDD VSS VSS gf180mcu_fd_sc_mcu7t5v0__fillcap_32
XFILLER_43_751 VDD VDD VSS VSS gf180mcu_fd_sc_mcu7t5v0__fillcap_16
XFILLER_62_559 VDD VDD VSS VSS gf180mcu_fd_sc_mcu7t5v0__fill_2
XTAP_TAPCELL_ROW_83_1365 VDD VSS gf180mcu_fd_sc_mcu7t5v0__filltie
XFILLER_63_72 VDD VDD VSS VSS gf180mcu_fd_sc_mcu7t5v0__fillcap_64
X_3440_ _4099_/Q _3442_/A3 _4100_/Q _3441_/B VDD VDD VSS VSS gf180mcu_fd_sc_mcu7t5v0__aoi21_1
X_3371_ _4084_/Q _3371_/A2 _3357_/Z _3371_/B _4084_/D VDD VDD VSS VSS gf180mcu_fd_sc_mcu7t5v0__oai31_2
XFILLER_112_734 VDD VDD VSS VSS gf180mcu_fd_sc_mcu7t5v0__fill_1
X_2322_ _2360_/A2 _3413_/A2 _2523_/A3 VDD VDD VSS VSS gf180mcu_fd_sc_mcu7t5v0__nor2_2
XFILLER_112_767 VDD VDD VSS VSS gf180mcu_fd_sc_mcu7t5v0__fillcap_4
XFILLER_69_136 VDD VDD VSS VSS gf180mcu_fd_sc_mcu7t5v0__fillcap_4
X_2253_ _2253_/I _2253_/ZN VDD VDD VSS VSS gf180mcu_fd_sc_mcu7t5v0__inv_1
XFILLER_97_489 VDD VDD VSS VSS gf180mcu_fd_sc_mcu7t5v0__fill_1
XFILLER_85_629 VDD VDD VSS VSS gf180mcu_fd_sc_mcu7t5v0__fill_1
XFILLER_26_2 VDD VDD VSS VSS gf180mcu_fd_sc_mcu7t5v0__fillcap_32
X_2184_ _2185_/A1 _3889_/Q _2185_/B VDD VDD VSS VSS gf180mcu_fd_sc_mcu7t5v0__nor2_1
XFILLER_25_206 VDD VDD VSS VSS gf180mcu_fd_sc_mcu7t5v0__fillcap_4
XFILLER_53_504 VDD VDD VSS VSS gf180mcu_fd_sc_mcu7t5v0__fill_1
XFILLER_80_312 VDD VDD VSS VSS gf180mcu_fd_sc_mcu7t5v0__fill_2
XTAP_TAPCELL_ROW_36_757 VDD VSS gf180mcu_fd_sc_mcu7t5v0__filltie
XFILLER_34_773 VDD VDD VSS VSS gf180mcu_fd_sc_mcu7t5v0__fill_2
XTAP_TAPCELL_ROW_16_492 VDD VSS gf180mcu_fd_sc_mcu7t5v0__filltie
X_1968_ _1968_/I _1969_/A1 VDD VDD VSS VSS gf180mcu_fd_sc_mcu7t5v0__clkinv_1
X_1899_ _1899_/A1 _1899_/A2 _1899_/A3 _1899_/A4 _1899_/Z VDD VDD VSS VSS gf180mcu_fd_sc_mcu7t5v0__or4_2
X_3707_ _3707_/D _4072_/CLK _3707_/Q VDD VDD VSS VSS gf180mcu_fd_sc_mcu7t5v0__dffq_1
X_3638_ _3638_/D _4157_/CLK _3638_/Q VDD VDD VSS VSS gf180mcu_fd_sc_mcu7t5v0__dffq_1
XFILLER_108_68 VDD VDD VSS VSS gf180mcu_fd_sc_mcu7t5v0__fillcap_32
XFILLER_1_806 VDD VDD VSS VSS gf180mcu_fd_sc_mcu7t5v0__fillcap_32
X_3569_ _3872_/Q _3880_/Q _3768_/Q _3776_/Q place76/Z place75/Z _3569_/Z VDD VDD VSS
+ VSS gf180mcu_fd_sc_mcu7t5v0__mux4_1
XFILLER_0_305 VDD VDD VSS VSS gf180mcu_fd_sc_mcu7t5v0__fill_1
XFILLER_130_553 VDD VDD VSS VSS gf180mcu_fd_sc_mcu7t5v0__fillcap_8
XFILLER_102_244 VDD VDD VSS VSS gf180mcu_fd_sc_mcu7t5v0__fill_1
XFILLER_130_597 VDD VDD VSS VSS gf180mcu_fd_sc_mcu7t5v0__fillcap_16
XFILLER_48_309 VDD VDD VSS VSS gf180mcu_fd_sc_mcu7t5v0__fillcap_4
XFILLER_124_89 VDD VDD VSS VSS gf180mcu_fd_sc_mcu7t5v0__fillcap_16
XFILLER_84_27 VDD VDD VSS VSS gf180mcu_fd_sc_mcu7t5v0__fillcap_8
XFILLER_29_523 VDD VDD VSS VSS gf180mcu_fd_sc_mcu7t5v0__fillcap_8
XFILLER_83_150 VDD VDD VSS VSS gf180mcu_fd_sc_mcu7t5v0__fill_2
XFILLER_71_334 VDD VDD VSS VSS gf180mcu_fd_sc_mcu7t5v0__fill_2
XFILLER_12_423 VDD VDD VSS VSS gf180mcu_fd_sc_mcu7t5v0__fill_2
XFILLER_9_906 VDD VDD VSS VSS gf180mcu_fd_sc_mcu7t5v0__fillcap_4
XFILLER_52_592 VDD VDD VSS VSS gf180mcu_fd_sc_mcu7t5v0__fill_2
XFILLER_9_928 VDD VDD VSS VSS gf180mcu_fd_sc_mcu7t5v0__fillcap_4
XPHY_EDGE_ROW_18_Left_151 VDD VSS gf180mcu_fd_sc_mcu7t5v0__endcap
XFILLER_106_594 VDD VDD VSS VSS gf180mcu_fd_sc_mcu7t5v0__fill_1
XFILLER_74_172 VDD VDD VSS VSS gf180mcu_fd_sc_mcu7t5v0__fill_2
XFILLER_35_515 VDD VDD VSS VSS gf180mcu_fd_sc_mcu7t5v0__fill_2
XPHY_EDGE_ROW_27_Left_160 VDD VSS gf180mcu_fd_sc_mcu7t5v0__endcap
XFILLER_35_559 VDD VDD VSS VSS gf180mcu_fd_sc_mcu7t5v0__fill_1
XFILLER_16_773 VDD VDD VSS VSS gf180mcu_fd_sc_mcu7t5v0__fill_2
XTAP_TAPCELL_ROW_33_716 VDD VSS gf180mcu_fd_sc_mcu7t5v0__filltie
X_1822_ _3887_/Q _3888_/Q _3885_/Q _3886_/Q _1822_/Z VDD VDD VSS VSS gf180mcu_fd_sc_mcu7t5v0__or4_4
XTAP_TAPCELL_ROW_13_451 VDD VSS gf180mcu_fd_sc_mcu7t5v0__filltie
XFILLER_31_765 VDD VDD VSS VSS gf180mcu_fd_sc_mcu7t5v0__fillcap_4
XTAP_TAPCELL_ROW_96_1534 VDD VSS gf180mcu_fd_sc_mcu7t5v0__filltie
X_3423_ _4103_/Q _3520_/A2 _3425_/A2 VDD VDD VSS VSS gf180mcu_fd_sc_mcu7t5v0__nor2_1
X_3354_ _3347_/B _3354_/A2 _3354_/B _3355_/A2 VDD VDD VSS VSS gf180mcu_fd_sc_mcu7t5v0__oai21_1
X_2305_ _3637_/Q place82/Z _2319_/S _3637_/D VDD VDD VSS VSS gf180mcu_fd_sc_mcu7t5v0__mux2_2
X_3285_ _4079_/Q _1953_/Z _3284_/Z _3285_/Z VDD VDD VSS VSS gf180mcu_fd_sc_mcu7t5v0__and3_1
X_2236_ _2236_/A1 _2236_/A2 _2236_/ZN VDD VDD VSS VSS gf180mcu_fd_sc_mcu7t5v0__nand2_1
XFILLER_100_737 VDD VDD VSS VSS gf180mcu_fd_sc_mcu7t5v0__fillcap_16
XFILLER_57_139 VDD VDD VSS VSS gf180mcu_fd_sc_mcu7t5v0__fill_1
X_2167_ _4127_/Q _2167_/A2 _2167_/B1 _2185_/A1 _2168_/A2 VDD VDD VSS VSS gf180mcu_fd_sc_mcu7t5v0__aoi22_1
XFILLER_81_632 VDD VDD VSS VSS gf180mcu_fd_sc_mcu7t5v0__fill_2
X_2098_ place71/Z place52/Z _2098_/A3 _2099_/B VDD VDD VSS VSS gf180mcu_fd_sc_mcu7t5v0__nand3_1
XTAP_TAPCELL_ROW_105_1652 VDD VSS gf180mcu_fd_sc_mcu7t5v0__filltie
XFILLER_34_592 VDD VDD VSS VSS gf180mcu_fd_sc_mcu7t5v0__fill_2
XFILLER_21_242 VDD VDD VSS VSS gf180mcu_fd_sc_mcu7t5v0__fill_1
XFILLER_6_909 VDD VDD VSS VSS gf180mcu_fd_sc_mcu7t5v0__fillcap_16
XFILLER_107_347 VDD VDD VSS VSS gf180mcu_fd_sc_mcu7t5v0__fill_2
XTAP_TAPCELL_ROW_56_1017 VDD VSS gf180mcu_fd_sc_mcu7t5v0__filltie
XFILLER_122_317 VDD VDD VSS VSS gf180mcu_fd_sc_mcu7t5v0__fillcap_8
XTAP_TAPCELL_ROW_116_1792 VDD VSS gf180mcu_fd_sc_mcu7t5v0__filltie
XFILLER_88_242 VDD VDD VSS VSS gf180mcu_fd_sc_mcu7t5v0__fill_2
XFILLER_44_334 VDD VDD VSS VSS gf180mcu_fd_sc_mcu7t5v0__fill_1
XFILLER_44_345 VDD VDD VSS VSS gf180mcu_fd_sc_mcu7t5v0__fill_1
XTAP_TAPCELL_ROW_67_1157 VDD VSS gf180mcu_fd_sc_mcu7t5v0__filltie
XFILLER_71_142 VDD VDD VSS VSS gf180mcu_fd_sc_mcu7t5v0__fillcap_8
XFILLER_44_378 VDD VDD VSS VSS gf180mcu_fd_sc_mcu7t5v0__fillcap_4
XTAP_TAPCELL_ROW_80_1324 VDD VSS gf180mcu_fd_sc_mcu7t5v0__filltie
XFILLER_53_890 VDD VDD VSS VSS gf180mcu_fd_sc_mcu7t5v0__fill_1
XTAP_TAPCELL_ROW_10_410 VDD VSS gf180mcu_fd_sc_mcu7t5v0__filltie
XFILLER_9_769 VDD VDD VSS VSS gf180mcu_fd_sc_mcu7t5v0__fill_1
XTAP_TAPCELL_ROW_10_421 VDD VSS gf180mcu_fd_sc_mcu7t5v0__filltie
XFILLER_114_807 VDD VDD VSS VSS gf180mcu_fd_sc_mcu7t5v0__fillcap_64
XTAP_TAPCELL_ROW_78_1297 VDD VSS gf180mcu_fd_sc_mcu7t5v0__filltie
XFILLER_5_35 VDD VDD VSS VSS gf180mcu_fd_sc_mcu7t5v0__fill_1
XFILLER_106_380 VDD VDD VSS VSS gf180mcu_fd_sc_mcu7t5v0__fillcap_4
XTAP_TAPCELL_ROW_91_1464 VDD VSS gf180mcu_fd_sc_mcu7t5v0__filltie
XFILLER_79_242 VDD VDD VSS VSS gf180mcu_fd_sc_mcu7t5v0__fillcap_4
XFILLER_95_702 VDD VDD VSS VSS gf180mcu_fd_sc_mcu7t5v0__fillcap_64
XTAP_TAPCELL_ROW_91_1475 VDD VSS gf180mcu_fd_sc_mcu7t5v0__filltie
XFILLER_79_286 VDD VDD VSS VSS gf180mcu_fd_sc_mcu7t5v0__fill_1
XFILLER_39_139 VDD VDD VSS VSS gf180mcu_fd_sc_mcu7t5v0__fill_1
XFILLER_94_267 VDD VDD VSS VSS gf180mcu_fd_sc_mcu7t5v0__fill_2
X_2021_ place52/Z _2021_/A2 _2022_/B VDD VDD VSS VSS gf180mcu_fd_sc_mcu7t5v0__nand2_1
XFILLER_63_632 VDD VDD VSS VSS gf180mcu_fd_sc_mcu7t5v0__fillcap_4
XFILLER_75_492 VDD VDD VSS VSS gf180mcu_fd_sc_mcu7t5v0__fillcap_64
XTAP_TAPCELL_ROW_18_521 VDD VSS gf180mcu_fd_sc_mcu7t5v0__filltie
XFILLER_35_334 VDD VDD VSS VSS gf180mcu_fd_sc_mcu7t5v0__fill_1
XFILLER_36_857 VDD VDD VSS VSS gf180mcu_fd_sc_mcu7t5v0__fillcap_16
XTAP_TAPCELL_ROW_46_885 VDD VSS gf180mcu_fd_sc_mcu7t5v0__filltie
XFILLER_63_687 VDD VDD VSS VSS gf180mcu_fd_sc_mcu7t5v0__fillcap_8
X_3972_ _3972_/D _2279_/I _3981_/CLK _3972_/Q VDD VDD VSS VSS gf180mcu_fd_sc_mcu7t5v0__dffrnq_1
XFILLER_93_2 VDD VDD VSS VSS gf180mcu_fd_sc_mcu7t5v0__fillcap_4
XFILLER_31_540 VDD VDD VSS VSS gf180mcu_fd_sc_mcu7t5v0__fillcap_8
XFILLER_31_562 VDD VDD VSS VSS gf180mcu_fd_sc_mcu7t5v0__fill_1
XTAP_TAPCELL_ROW_100_1582 VDD VSS gf180mcu_fd_sc_mcu7t5v0__filltie
X_1805_ _3891_/Q _3892_/Q _3889_/Q _3890_/Q _2013_/A4 VDD VDD VSS VSS gf180mcu_fd_sc_mcu7t5v0__nor4_4
X_2785_ place90/Z _3845_/Q _2799_/S _3845_/D VDD VDD VSS VSS gf180mcu_fd_sc_mcu7t5v0__mux2_2
XFILLER_116_111 VDD VDD VSS VSS gf180mcu_fd_sc_mcu7t5v0__fill_1
Xhold202 s_axi_awaddr[0] hold202/Z VDD VDD VSS VSS gf180mcu_fd_sc_mcu7t5v0__dlyc_1
Xhold224 s_axi_wdata[30] hold224/Z VDD VDD VSS VSS gf180mcu_fd_sc_mcu7t5v0__dlyc_1
Xhold213 s_axi_wdata[14] hold213/Z VDD VDD VSS VSS gf180mcu_fd_sc_mcu7t5v0__dlyc_1
XFILLER_116_177 VDD VDD VSS VSS gf180mcu_fd_sc_mcu7t5v0__fillcap_16
XFILLER_104_317 VDD VDD VSS VSS gf180mcu_fd_sc_mcu7t5v0__fillcap_16
X_3337_ _3337_/A1 _3337_/A2 _3337_/B1 _3337_/B2 _4077_/D VDD VDD VSS VSS gf180mcu_fd_sc_mcu7t5v0__aoi22_2
XFILLER_85_212 VDD VDD VSS VSS gf180mcu_fd_sc_mcu7t5v0__fillcap_8
Xload_slew182 _4157_/RN _4148_/RN VDD VDD VSS VSS gf180mcu_fd_sc_mcu7t5v0__buf_20
XFILLER_105_69 VDD VDD VSS VSS gf180mcu_fd_sc_mcu7t5v0__fill_1
X_3268_ _4062_/Q _3626_/A1 _3271_/A3 VDD VDD VSS VSS gf180mcu_fd_sc_mcu7t5v0__nand2_1
X_2219_ _2112_/I _2891_/A1 _2219_/B _2219_/C _2220_/B VDD VDD VSS VSS gf180mcu_fd_sc_mcu7t5v0__aoi211_1
XFILLER_22_573 VDD VDD VSS VSS gf180mcu_fd_sc_mcu7t5v0__fillcap_16
XTAP_TAPCELL_ROW_62_1087 VDD VSS gf180mcu_fd_sc_mcu7t5v0__filltie
XTAP_TAPCELL_ROW_118_1821 VDD VSS gf180mcu_fd_sc_mcu7t5v0__filltie
XTAP_TAPCELL_ROW_62_1098 VDD VSS gf180mcu_fd_sc_mcu7t5v0__filltie
XFILLER_6_728 VDD VDD VSS VSS gf180mcu_fd_sc_mcu7t5v0__fillcap_4
XFILLER_108_667 VDD VDD VSS VSS gf180mcu_fd_sc_mcu7t5v0__fill_2
XFILLER_107_133 VDD VDD VSS VSS gf180mcu_fd_sc_mcu7t5v0__fillcap_4
XFILLER_123_626 VDD VDD VSS VSS gf180mcu_fd_sc_mcu7t5v0__fillcap_4
XFILLER_123_648 VDD VDD VSS VSS gf180mcu_fd_sc_mcu7t5v0__fillcap_8
XFILLER_1_422 VDD VDD VSS VSS gf180mcu_fd_sc_mcu7t5v0__fillcap_16
XFILLER_110_309 VDD VDD VSS VSS gf180mcu_fd_sc_mcu7t5v0__fillcap_4
XFILLER_89_562 VDD VDD VSS VSS gf180mcu_fd_sc_mcu7t5v0__fillcap_64
XFILLER_77_702 VDD VDD VSS VSS gf180mcu_fd_sc_mcu7t5v0__fillcap_32
XFILLER_92_705 VDD VDD VSS VSS gf180mcu_fd_sc_mcu7t5v0__fill_1
XTAP_TAPCELL_ROW_129_1961 VDD VSS gf180mcu_fd_sc_mcu7t5v0__filltie
XFILLER_91_226 VDD VDD VSS VSS gf180mcu_fd_sc_mcu7t5v0__fillcap_32
XFILLER_57_470 VDD VDD VSS VSS gf180mcu_fd_sc_mcu7t5v0__fillcap_4
XFILLER_57_492 VDD VDD VSS VSS gf180mcu_fd_sc_mcu7t5v0__fillcap_32
XFILLER_45_698 VDD VDD VSS VSS gf180mcu_fd_sc_mcu7t5v0__fill_2
XFILLER_60_613 VDD VDD VSS VSS gf180mcu_fd_sc_mcu7t5v0__fillcap_8
XFILLER_72_451 VDD VDD VSS VSS gf180mcu_fd_sc_mcu7t5v0__fillcap_4
XTAP_TAPCELL_ROW_43_844 VDD VSS gf180mcu_fd_sc_mcu7t5v0__filltie
XFILLER_13_562 VDD VDD VSS VSS gf180mcu_fd_sc_mcu7t5v0__fillcap_8
XFILLER_71_72 VDD VDD VSS VSS gf180mcu_fd_sc_mcu7t5v0__fillcap_4
XTAP_TAPCELL_ROW_23_590 VDD VSS gf180mcu_fd_sc_mcu7t5v0__filltie
XFILLER_127_932 VDD VDD VSS VSS gf180mcu_fd_sc_mcu7t5v0__fill_2
X_2570_ _3754_/Q place80/Z _2574_/S _3754_/D VDD VDD VSS VSS gf180mcu_fd_sc_mcu7t5v0__mux2_2
XFILLER_5_772 VDD VDD VSS VSS gf180mcu_fd_sc_mcu7t5v0__fillcap_64
XFILLER_5_761 VDD VDD VSS VSS gf180mcu_fd_sc_mcu7t5v0__fillcap_8
XFILLER_68_713 VDD VDD VSS VSS gf180mcu_fd_sc_mcu7t5v0__fillcap_4
XFILLER_110_821 VDD VDD VSS VSS gf180mcu_fd_sc_mcu7t5v0__fill_1
XFILLER_67_212 VDD VDD VSS VSS gf180mcu_fd_sc_mcu7t5v0__fillcap_16
XFILLER_83_738 VDD VDD VSS VSS gf180mcu_fd_sc_mcu7t5v0__fill_2
X_2004_ _4157_/Q _4065_/Q _4126_/Q _2005_/B VDD VDD VSS VSS gf180mcu_fd_sc_mcu7t5v0__aoi21_1
XTAP_TAPCELL_ROW_102_1611 VDD VSS gf180mcu_fd_sc_mcu7t5v0__filltie
XFILLER_91_793 VDD VDD VSS VSS gf180mcu_fd_sc_mcu7t5v0__fill_1
XFILLER_63_484 VDD VDD VSS VSS gf180mcu_fd_sc_mcu7t5v0__fillcap_4
X_3955_ _3955_/D _2279_/I _3981_/CLK _3955_/Q VDD VDD VSS VSS gf180mcu_fd_sc_mcu7t5v0__dffrnq_1
XFILLER_32_893 VDD VDD VSS VSS gf180mcu_fd_sc_mcu7t5v0__fillcap_8
X_2906_ _4056_/Q _3519_/A2 _3519_/A3 place66/I VDD VDD VSS VSS gf180mcu_fd_sc_mcu7t5v0__nand3_1
X_3886_ _3886_/D _4148_/RN _4057_/CLK _3886_/Q VDD VDD VSS VSS gf180mcu_fd_sc_mcu7t5v0__dffsnq_1
XFILLER_118_932 VDD VDD VSS VSS gf180mcu_fd_sc_mcu7t5v0__fill_2
X_2768_ place90/Z _3837_/Q _2782_/S _3837_/D VDD VDD VSS VSS gf180mcu_fd_sc_mcu7t5v0__mux2_2
XFILLER_105_626 VDD VDD VSS VSS gf180mcu_fd_sc_mcu7t5v0__fillcap_4
XTAP_TAPCELL_ROW_113_1751 VDD VSS gf180mcu_fd_sc_mcu7t5v0__filltie
XFILLER_105_659 VDD VDD VSS VSS gf180mcu_fd_sc_mcu7t5v0__fillcap_32
XFILLER_132_478 VDD VDD VSS VSS gf180mcu_fd_sc_mcu7t5v0__fill_1
XFILLER_59_702 VDD VDD VSS VSS gf180mcu_fd_sc_mcu7t5v0__fillcap_8
XFILLER_76_39 VDD VDD VSS VSS gf180mcu_fd_sc_mcu7t5v0__fill_1
XFILLER_58_201 VDD VDD VSS VSS gf180mcu_fd_sc_mcu7t5v0__fill_2
XFILLER_86_543 VDD VDD VSS VSS gf180mcu_fd_sc_mcu7t5v0__fillcap_4
XFILLER_47_908 VDD VDD VSS VSS gf180mcu_fd_sc_mcu7t5v0__fill_2
XFILLER_58_267 VDD VDD VSS VSS gf180mcu_fd_sc_mcu7t5v0__fill_2
XFILLER_101_898 VDD VDD VSS VSS gf180mcu_fd_sc_mcu7t5v0__fillcap_8
XFILLER_27_610 VDD VDD VSS VSS gf180mcu_fd_sc_mcu7t5v0__fillcap_4
XFILLER_27_621 VDD VDD VSS VSS gf180mcu_fd_sc_mcu7t5v0__fillcap_8
XFILLER_132_78 VDD VDD VSS VSS gf180mcu_fd_sc_mcu7t5v0__fillcap_4
XFILLER_92_27 VDD VDD VSS VSS gf180mcu_fd_sc_mcu7t5v0__fillcap_8
Xplace49 place49/I _2503_/S VDD VDD VSS VSS gf180mcu_fd_sc_mcu7t5v0__buf_8
XFILLER_27_632 VDD VDD VSS VSS gf180mcu_fd_sc_mcu7t5v0__fillcap_16
XFILLER_39_492 VDD VDD VSS VSS gf180mcu_fd_sc_mcu7t5v0__fillcap_32
XFILLER_26_142 VDD VDD VSS VSS gf180mcu_fd_sc_mcu7t5v0__fillcap_32
XFILLER_54_451 VDD VDD VSS VSS gf180mcu_fd_sc_mcu7t5v0__fillcap_4
XTAP_TAPCELL_ROW_1_296 VDD VSS gf180mcu_fd_sc_mcu7t5v0__filltie
XTAP_TAPCELL_ROW_64_1116 VDD VSS gf180mcu_fd_sc_mcu7t5v0__filltie
XFILLER_70_933 VDD VDD VSS VSS gf180mcu_fd_sc_mcu7t5v0__fill_1
XFILLER_25_65 VDD VDD VSS VSS gf180mcu_fd_sc_mcu7t5v0__fillcap_4
XTAP_TAPCELL_ROW_40_803 VDD VSS gf180mcu_fd_sc_mcu7t5v0__filltie
XFILLER_41_134 VDD VDD VSS VSS gf180mcu_fd_sc_mcu7t5v0__fillcap_4
XFILLER_23_893 VDD VDD VSS VSS gf180mcu_fd_sc_mcu7t5v0__fill_2
XFILLER_25_98 VDD VDD VSS VSS gf180mcu_fd_sc_mcu7t5v0__fill_1
XFILLER_10_543 VDD VDD VSS VSS gf180mcu_fd_sc_mcu7t5v0__fillcap_4
XFILLER_10_521 VDD VDD VSS VSS gf180mcu_fd_sc_mcu7t5v0__fillcap_4
XFILLER_22_381 VDD VDD VSS VSS gf180mcu_fd_sc_mcu7t5v0__fillcap_4
XFILLER_109_932 VDD VDD VSS VSS gf180mcu_fd_sc_mcu7t5v0__fill_2
XTAP_TAPCELL_ROW_75_1267 VDD VSS gf180mcu_fd_sc_mcu7t5v0__filltie
XTAP_TAPCELL_ROW_75_1256 VDD VSS gf180mcu_fd_sc_mcu7t5v0__filltie
XFILLER_110_139 VDD VDD VSS VSS gf180mcu_fd_sc_mcu7t5v0__fillcap_8
XFILLER_89_392 VDD VDD VSS VSS gf180mcu_fd_sc_mcu7t5v0__fillcap_16
XFILLER_49_212 VDD VDD VSS VSS gf180mcu_fd_sc_mcu7t5v0__fillcap_64
XFILLER_92_524 VDD VDD VSS VSS gf180mcu_fd_sc_mcu7t5v0__fill_1
XTAP_TAPCELL_ROW_48_914 VDD VSS gf180mcu_fd_sc_mcu7t5v0__filltie
XFILLER_17_120 VDD VDD VSS VSS gf180mcu_fd_sc_mcu7t5v0__fill_2
XFILLER_18_687 VDD VDD VSS VSS gf180mcu_fd_sc_mcu7t5v0__fill_2
XFILLER_17_142 VDD VDD VSS VSS gf180mcu_fd_sc_mcu7t5v0__fillcap_64
XFILLER_45_473 VDD VDD VSS VSS gf180mcu_fd_sc_mcu7t5v0__fill_2
XFILLER_32_101 VDD VDD VSS VSS gf180mcu_fd_sc_mcu7t5v0__fillcap_4
XFILLER_33_624 VDD VDD VSS VSS gf180mcu_fd_sc_mcu7t5v0__fillcap_4
XFILLER_61_933 VDD VDD VSS VSS gf180mcu_fd_sc_mcu7t5v0__fill_1
XFILLER_72_281 VDD VDD VSS VSS gf180mcu_fd_sc_mcu7t5v0__fillcap_32
XFILLER_60_454 VDD VDD VSS VSS gf180mcu_fd_sc_mcu7t5v0__fill_1
XFILLER_60_465 VDD VDD VSS VSS gf180mcu_fd_sc_mcu7t5v0__fill_2
XFILLER_20_307 VDD VDD VSS VSS gf180mcu_fd_sc_mcu7t5v0__fillcap_8
X_3740_ _3740_/D _3740_/CLK _3740_/Q VDD VDD VSS VSS gf180mcu_fd_sc_mcu7t5v0__dffq_1
XFILLER_119_718 VDD VDD VSS VSS gf180mcu_fd_sc_mcu7t5v0__fillcap_8
XFILLER_13_381 VDD VDD VSS VSS gf180mcu_fd_sc_mcu7t5v0__fill_1
XFILLER_9_352 VDD VDD VSS VSS gf180mcu_fd_sc_mcu7t5v0__fillcap_64
XFILLER_118_217 VDD VDD VSS VSS gf180mcu_fd_sc_mcu7t5v0__fill_1
X_3671_ _3671_/D _3750_/CLK _3671_/Q VDD VDD VSS VSS gf180mcu_fd_sc_mcu7t5v0__dffq_1
X_2622_ _2748_/A1 _3537_/A1 _3542_/A3 VDD VDD VSS VSS gf180mcu_fd_sc_mcu7t5v0__nor2_1
XFILLER_126_261 VDD VDD VSS VSS gf180mcu_fd_sc_mcu7t5v0__fillcap_32
XFILLER_56_2 VDD VDD VSS VSS gf180mcu_fd_sc_mcu7t5v0__fillcap_16
Xoutput159 _2253_/ZN s_axi_rdata[20] VDD VDD VSS VSS gf180mcu_fd_sc_mcu7t5v0__dlyb_1
Xoutput148 _2230_/ZN s_axi_rdata[10] VDD VDD VSS VSS gf180mcu_fd_sc_mcu7t5v0__dlyb_1
XFILLER_114_489 VDD VDD VSS VSS gf180mcu_fd_sc_mcu7t5v0__fillcap_16
XFILLER_99_189 VDD VDD VSS VSS gf180mcu_fd_sc_mcu7t5v0__fillcap_16
XFILLER_101_139 VDD VDD VSS VSS gf180mcu_fd_sc_mcu7t5v0__fill_1
X_4154_ _4154_/D _4157_/RN _4156_/CLK _4154_/Q VDD VDD VSS VSS gf180mcu_fd_sc_mcu7t5v0__dffrnq_1
XFILLER_95_384 VDD VDD VSS VSS gf180mcu_fd_sc_mcu7t5v0__fillcap_16
X_4085_ _4085_/D _2279_/I _4126_/CLK _4085_/Q VDD VDD VSS VSS gf180mcu_fd_sc_mcu7t5v0__dffrnq_1
XFILLER_83_524 VDD VDD VSS VSS gf180mcu_fd_sc_mcu7t5v0__fill_2
XFILLER_24_602 VDD VDD VSS VSS gf180mcu_fd_sc_mcu7t5v0__fillcap_32
XTAP_TAPCELL_ROW_26_619 VDD VSS gf180mcu_fd_sc_mcu7t5v0__filltie
XFILLER_55_259 VDD VDD VSS VSS gf180mcu_fd_sc_mcu7t5v0__fill_2
XFILLER_36_473 VDD VDD VSS VSS gf180mcu_fd_sc_mcu7t5v0__fill_2
XFILLER_52_933 VDD VDD VSS VSS gf180mcu_fd_sc_mcu7t5v0__fill_1
XFILLER_12_819 VDD VDD VSS VSS gf180mcu_fd_sc_mcu7t5v0__fill_2
XFILLER_23_134 VDD VDD VSS VSS gf180mcu_fd_sc_mcu7t5v0__fillcap_4
XFILLER_23_178 VDD VDD VSS VSS gf180mcu_fd_sc_mcu7t5v0__fillcap_32
X_3938_ _3938_/D _2279_/I _4126_/CLK _3938_/Q VDD VDD VSS VSS gf180mcu_fd_sc_mcu7t5v0__dffrnq_1
X_3869_ _3869_/D _4148_/CLK _3869_/Q VDD VDD VSS VSS gf180mcu_fd_sc_mcu7t5v0__dffq_1
XTAP_TAPCELL_ROW_6_366 VDD VSS gf180mcu_fd_sc_mcu7t5v0__filltie
XFILLER_86_384 VDD VDD VSS VSS gf180mcu_fd_sc_mcu7t5v0__fill_1
XFILLER_59_576 VDD VDD VSS VSS gf180mcu_fd_sc_mcu7t5v0__fill_1
XTAP_TAPCELL_ROW_70_1197 VDD VSS gf180mcu_fd_sc_mcu7t5v0__filltie
XTAP_TAPCELL_ROW_126_1920 VDD VSS gf180mcu_fd_sc_mcu7t5v0__filltie
XTAP_TAPCELL_ROW_53_972 VDD VSS gf180mcu_fd_sc_mcu7t5v0__filltie
XFILLER_6_311 VDD VDD VSS VSS gf180mcu_fd_sc_mcu7t5v0__fillcap_4
XFILLER_10_373 VDD VDD VSS VSS gf180mcu_fd_sc_mcu7t5v0__fillcap_8
XFILLER_6_399 VDD VDD VSS VSS gf180mcu_fd_sc_mcu7t5v0__fill_1
XFILLER_124_798 VDD VDD VSS VSS gf180mcu_fd_sc_mcu7t5v0__fillcap_4
XFILLER_96_104 VDD VDD VSS VSS gf180mcu_fd_sc_mcu7t5v0__fill_1
XFILLER_78_874 VDD VDD VSS VSS gf180mcu_fd_sc_mcu7t5v0__fill_1
XFILLER_77_60 VDD VDD VSS VSS gf180mcu_fd_sc_mcu7t5v0__fillcap_8
XTAP_TAPCELL_ROW_88_1425 VDD VSS gf180mcu_fd_sc_mcu7t5v0__filltie
XFILLER_65_524 VDD VDD VSS VSS gf180mcu_fd_sc_mcu7t5v0__fillcap_16
XFILLER_92_343 VDD VDD VSS VSS gf180mcu_fd_sc_mcu7t5v0__fillcap_4
XTAP_TAPCELL_ROW_88_1436 VDD VSS gf180mcu_fd_sc_mcu7t5v0__filltie
XFILLER_37_259 VDD VDD VSS VSS gf180mcu_fd_sc_mcu7t5v0__fillcap_16
XFILLER_92_387 VDD VDD VSS VSS gf180mcu_fd_sc_mcu7t5v0__fillcap_16
XFILLER_80_527 VDD VDD VSS VSS gf180mcu_fd_sc_mcu7t5v0__fillcap_8
XFILLER_20_104 VDD VDD VSS VSS gf180mcu_fd_sc_mcu7t5v0__fill_1
XFILLER_60_262 VDD VDD VSS VSS gf180mcu_fd_sc_mcu7t5v0__fillcap_4
X_1984_ _3385_/A2 _3966_/Q _1987_/B1 VDD VDD VSS VSS gf180mcu_fd_sc_mcu7t5v0__nand2_1
XFILLER_20_115 VDD VDD VSS VSS gf180mcu_fd_sc_mcu7t5v0__fillcap_4
X_3723_ _3723_/D _3740_/CLK _3723_/Q VDD VDD VSS VSS gf180mcu_fd_sc_mcu7t5v0__dffq_1
XFILLER_119_559 VDD VDD VSS VSS gf180mcu_fd_sc_mcu7t5v0__fill_1
XTAP_TAPCELL_ROW_99_1576 VDD VSS gf180mcu_fd_sc_mcu7t5v0__filltie
X_3654_ _3654_/D _3732_/CLK _3654_/Q VDD VDD VSS VSS gf180mcu_fd_sc_mcu7t5v0__dffq_1
XTAP_TAPCELL_ROW_31_688 VDD VSS gf180mcu_fd_sc_mcu7t5v0__filltie
XFILLER_127_570 VDD VDD VSS VSS gf180mcu_fd_sc_mcu7t5v0__fillcap_4
X_2605_ place90/Z _3765_/Q _2619_/S _3765_/D VDD VDD VSS VSS gf180mcu_fd_sc_mcu7t5v0__mux2_2
X_3585_ _3581_/Z _3582_/Z _3583_/Z _3584_/Z place74/Z _4119_/Q _3585_/Z VDD VDD VSS
+ VSS gf180mcu_fd_sc_mcu7t5v0__mux4_1
XFILLER_0_509 VDD VDD VSS VSS gf180mcu_fd_sc_mcu7t5v0__fill_1
X_2536_ _4073_/Q _3739_/Q _2538_/S _3739_/D VDD VDD VSS VSS gf180mcu_fd_sc_mcu7t5v0__mux2_2
XTAP_TAPCELL_ROW_110_1721 VDD VSS gf180mcu_fd_sc_mcu7t5v0__filltie
XTAP_TAPCELL_ROW_110_1710 VDD VSS gf180mcu_fd_sc_mcu7t5v0__filltie
XFILLER_87_104 VDD VDD VSS VSS gf180mcu_fd_sc_mcu7t5v0__fill_2
XFILLER_69_830 VDD VDD VSS VSS gf180mcu_fd_sc_mcu7t5v0__fillcap_8
XFILLER_130_757 VDD VDD VSS VSS gf180mcu_fd_sc_mcu7t5v0__fillcap_8
X_2398_ place82/Z _3677_/Q _2412_/S _3677_/D VDD VDD VSS VSS gf180mcu_fd_sc_mcu7t5v0__mux2_2
XTAP_TAPCELL_ROW_3_325 VDD VSS gf180mcu_fd_sc_mcu7t5v0__filltie
X_4137_ _4137_/D _4148_/RN _4138_/CLK _4137_/Q VDD VDD VSS VSS gf180mcu_fd_sc_mcu7t5v0__dffrnq_1
XFILLER_113_47 VDD VDD VSS VSS gf180mcu_fd_sc_mcu7t5v0__fill_2
XFILLER_84_877 VDD VDD VSS VSS gf180mcu_fd_sc_mcu7t5v0__fillcap_8
XFILLER_71_516 VDD VDD VSS VSS gf180mcu_fd_sc_mcu7t5v0__fillcap_4
X_4068_ _4068_/D input92/Z _4166_/CLK _4068_/Q VDD VDD VSS VSS gf180mcu_fd_sc_mcu7t5v0__dffrnq_1
X_3019_ _3953_/Q _4041_/Q _3041_/S _3953_/D VDD VDD VSS VSS gf180mcu_fd_sc_mcu7t5v0__mux2_2
XTAP_TAPCELL_ROW_39_788 VDD VSS gf180mcu_fd_sc_mcu7t5v0__filltie
XTAP_TAPCELL_ROW_39_799 VDD VSS gf180mcu_fd_sc_mcu7t5v0__filltie
XTAP_TAPCELL_ROW_108_1694 VDD VSS gf180mcu_fd_sc_mcu7t5v0__filltie
XFILLER_52_752 VDD VDD VSS VSS gf180mcu_fd_sc_mcu7t5v0__fillcap_8
XTAP_TAPCELL_ROW_121_1861 VDD VSS gf180mcu_fd_sc_mcu7t5v0__filltie
XFILLER_12_605 VDD VDD VSS VSS gf180mcu_fd_sc_mcu7t5v0__fillcap_4
XFILLER_11_104 VDD VDD VSS VSS gf180mcu_fd_sc_mcu7t5v0__fill_1
XTAP_TAPCELL_ROW_50_931 VDD VSS gf180mcu_fd_sc_mcu7t5v0__filltie
XTAP_TAPCELL_ROW_50_942 VDD VSS gf180mcu_fd_sc_mcu7t5v0__filltie
XTAP_TAPCELL_ROW_59_1048 VDD VSS gf180mcu_fd_sc_mcu7t5v0__filltie
XFILLER_106_732 VDD VDD VSS VSS gf180mcu_fd_sc_mcu7t5v0__fill_2
XTAP_TAPCELL_ROW_59_1059 VDD VSS gf180mcu_fd_sc_mcu7t5v0__filltie
XFILLER_121_702 VDD VDD VSS VSS gf180mcu_fd_sc_mcu7t5v0__fillcap_8
XTAP_TAPCELL_ROW_72_1226 VDD VSS gf180mcu_fd_sc_mcu7t5v0__filltie
XFILLER_3_347 VDD VDD VSS VSS gf180mcu_fd_sc_mcu7t5v0__fill_2
XFILLER_101_470 VDD VDD VSS VSS gf180mcu_fd_sc_mcu7t5v0__fillcap_16
XFILLER_86_181 VDD VDD VSS VSS gf180mcu_fd_sc_mcu7t5v0__fill_2
XFILLER_47_568 VDD VDD VSS VSS gf180mcu_fd_sc_mcu7t5v0__fill_1
XFILLER_62_505 VDD VDD VSS VSS gf180mcu_fd_sc_mcu7t5v0__fillcap_4
XFILLER_74_387 VDD VDD VSS VSS gf180mcu_fd_sc_mcu7t5v0__fillcap_16
XFILLER_16_933 VDD VDD VSS VSS gf180mcu_fd_sc_mcu7t5v0__fill_1
XFILLER_62_527 VDD VDD VSS VSS gf180mcu_fd_sc_mcu7t5v0__fillcap_32
XFILLER_15_454 VDD VDD VSS VSS gf180mcu_fd_sc_mcu7t5v0__fillcap_8
XTAP_TAPCELL_ROW_83_1366 VDD VSS gf180mcu_fd_sc_mcu7t5v0__filltie
XFILLER_30_435 VDD VDD VSS VSS gf180mcu_fd_sc_mcu7t5v0__fill_2
XFILLER_70_593 VDD VDD VSS VSS gf180mcu_fd_sc_mcu7t5v0__fill_2
XFILLER_30_457 VDD VDD VSS VSS gf180mcu_fd_sc_mcu7t5v0__fillcap_16
XFILLER_128_345 VDD VDD VSS VSS gf180mcu_fd_sc_mcu7t5v0__fillcap_8
XFILLER_128_378 VDD VDD VSS VSS gf180mcu_fd_sc_mcu7t5v0__fillcap_4
XFILLER_7_686 VDD VDD VSS VSS gf180mcu_fd_sc_mcu7t5v0__fillcap_8
XFILLER_98_925 VDD VDD VSS VSS gf180mcu_fd_sc_mcu7t5v0__fillcap_8
X_3370_ _3370_/A1 _3370_/A2 _4084_/Q _3371_/B VDD VDD VSS VSS gf180mcu_fd_sc_mcu7t5v0__oai21_1
XFILLER_111_212 VDD VDD VSS VSS gf180mcu_fd_sc_mcu7t5v0__fillcap_64
X_2321_ _4096_/Q _4095_/Q _3407_/A2 _3413_/A2 VDD VDD VSS VSS gf180mcu_fd_sc_mcu7t5v0__nand3_1
X_2252_ _3953_/Q place63/Z place67/Z _3978_/Q _3921_/Q place72/Z _2253_/I VDD VDD
+ VSS VSS gf180mcu_fd_sc_mcu7t5v0__aoi222_1
XFILLER_97_446 VDD VDD VSS VSS gf180mcu_fd_sc_mcu7t5v0__fillcap_4
XFILLER_2_391 VDD VDD VSS VSS gf180mcu_fd_sc_mcu7t5v0__fill_2
XFILLER_69_159 VDD VDD VSS VSS gf180mcu_fd_sc_mcu7t5v0__fillcap_32
XFILLER_84_107 VDD VDD VSS VSS gf180mcu_fd_sc_mcu7t5v0__fillcap_64
XFILLER_38_513 VDD VDD VSS VSS gf180mcu_fd_sc_mcu7t5v0__fillcap_8
XFILLER_19_2 VDD VDD VSS VSS gf180mcu_fd_sc_mcu7t5v0__fillcap_16
X_2183_ _4104_/Q _2182_/Z _3065_/A1 VDD VDD VSS VSS gf180mcu_fd_sc_mcu7t5v0__nor2_1
XFILLER_66_877 VDD VDD VSS VSS gf180mcu_fd_sc_mcu7t5v0__fillcap_32
XFILLER_93_696 VDD VDD VSS VSS gf180mcu_fd_sc_mcu7t5v0__fillcap_4
XFILLER_92_184 VDD VDD VSS VSS gf180mcu_fd_sc_mcu7t5v0__fillcap_16
XTAP_TAPCELL_ROW_36_758 VDD VSS gf180mcu_fd_sc_mcu7t5v0__filltie
XFILLER_80_379 VDD VDD VSS VSS gf180mcu_fd_sc_mcu7t5v0__fillcap_4
XTAP_TAPCELL_ROW_16_493 VDD VSS gf180mcu_fd_sc_mcu7t5v0__filltie
X_3706_ _3706_/D _4098_/CLK _3706_/Q VDD VDD VSS VSS gf180mcu_fd_sc_mcu7t5v0__dffq_1
X_1898_ _1910_/S _1898_/A2 _1898_/B1 _4137_/Q _1899_/A4 VDD VDD VSS VSS gf180mcu_fd_sc_mcu7t5v0__aoi22_1
X_3637_ _3637_/D _3749_/CLK _3637_/Q VDD VDD VSS VSS gf180mcu_fd_sc_mcu7t5v0__dffq_1
XFILLER_103_702 VDD VDD VSS VSS gf180mcu_fd_sc_mcu7t5v0__fillcap_64
X_3568_ _3840_/Q _3848_/Q _3856_/Q _3864_/Q place76/Z place75/Z _3568_/Z VDD VDD VSS
+ VSS gf180mcu_fd_sc_mcu7t5v0__mux4_1
XFILLER_115_562 VDD VDD VSS VSS gf180mcu_fd_sc_mcu7t5v0__fillcap_16
X_2519_ _3731_/Q _4073_/Q _2521_/S _3731_/D VDD VDD VSS VSS gf180mcu_fd_sc_mcu7t5v0__mux2_2
XFILLER_88_457 VDD VDD VSS VSS gf180mcu_fd_sc_mcu7t5v0__fillcap_64
XFILLER_88_435 VDD VDD VSS VSS gf180mcu_fd_sc_mcu7t5v0__fillcap_8
XFILLER_84_663 VDD VDD VSS VSS gf180mcu_fd_sc_mcu7t5v0__fill_2
XFILLER_84_696 VDD VDD VSS VSS gf180mcu_fd_sc_mcu7t5v0__fillcap_32
XFILLER_44_527 VDD VDD VSS VSS gf180mcu_fd_sc_mcu7t5v0__fillcap_64
XFILLER_72_869 VDD VDD VSS VSS gf180mcu_fd_sc_mcu7t5v0__fillcap_4
XFILLER_17_66 VDD VDD VSS VSS gf180mcu_fd_sc_mcu7t5v0__fillcap_4
XFILLER_12_457 VDD VDD VSS VSS gf180mcu_fd_sc_mcu7t5v0__fillcap_8
XFILLER_123_2 VDD VDD VSS VSS gf180mcu_fd_sc_mcu7t5v0__fillcap_4
XFILLER_95_906 VDD VDD VSS VSS gf180mcu_fd_sc_mcu7t5v0__fillcap_4
XFILLER_95_928 VDD VDD VSS VSS gf180mcu_fd_sc_mcu7t5v0__fillcap_4
XFILLER_66_107 VDD VDD VSS VSS gf180mcu_fd_sc_mcu7t5v0__fillcap_8
XFILLER_94_438 VDD VDD VSS VSS gf180mcu_fd_sc_mcu7t5v0__fillcap_16
XFILLER_58_95 VDD VDD VSS VSS gf180mcu_fd_sc_mcu7t5v0__fillcap_8
XFILLER_48_877 VDD VDD VSS VSS gf180mcu_fd_sc_mcu7t5v0__fillcap_16
XFILLER_63_836 VDD VDD VSS VSS gf180mcu_fd_sc_mcu7t5v0__fillcap_4
XFILLER_74_83 VDD VDD VSS VSS gf180mcu_fd_sc_mcu7t5v0__fillcap_16
XFILLER_16_730 VDD VDD VSS VSS gf180mcu_fd_sc_mcu7t5v0__fillcap_4
XTAP_TAPCELL_ROW_33_717 VDD VSS gf180mcu_fd_sc_mcu7t5v0__filltie
XFILLER_95_6 VDD VDD VSS VSS gf180mcu_fd_sc_mcu7t5v0__fill_2
X_2870_ _3519_/A1 _4057_/Q _2870_/A3 place54/I VDD VDD VSS VSS gf180mcu_fd_sc_mcu7t5v0__nor3_1
XFILLER_129_632 VDD VDD VSS VSS gf180mcu_fd_sc_mcu7t5v0__fillcap_4
XTAP_TAPCELL_ROW_13_452 VDD VSS gf180mcu_fd_sc_mcu7t5v0__filltie
XTAP_TAPCELL_ROW_96_1535 VDD VSS gf180mcu_fd_sc_mcu7t5v0__filltie
Xclkbuf_leaf_10_clk clkload1/I _4028_/CLK VDD VDD VSS VSS gf180mcu_fd_sc_mcu7t5v0__clkbuf_8
X_3422_ _3485_/A1 _3973_/Q _3520_/A2 VDD VDD VSS VSS gf180mcu_fd_sc_mcu7t5v0__nand2_1
X_3353_ _4078_/Q _3353_/A2 _3353_/B _4079_/Q _3354_/A2 VDD VDD VSS VSS gf180mcu_fd_sc_mcu7t5v0__oai211_1
XFILLER_98_788 VDD VDD VSS VSS gf180mcu_fd_sc_mcu7t5v0__fill_1
XFILLER_86_928 VDD VDD VSS VSS gf180mcu_fd_sc_mcu7t5v0__fillcap_4
X_3284_ _4078_/Q _3353_/B _3284_/Z VDD VDD VSS VSS gf180mcu_fd_sc_mcu7t5v0__and2_1
X_2235_ _3897_/Q place68/Z place63/Z _3945_/Q place67/Z _4089_/Q _2236_/A2 VDD VDD
+ VSS VSS gf180mcu_fd_sc_mcu7t5v0__aoi222_1
X_2166_ _2152_/S _3516_/A1 _2166_/B _2167_/B1 VDD VDD VSS VSS gf180mcu_fd_sc_mcu7t5v0__oai21_1
XFILLER_54_803 VDD VDD VSS VSS gf180mcu_fd_sc_mcu7t5v0__fill_2
XFILLER_66_652 VDD VDD VSS VSS gf180mcu_fd_sc_mcu7t5v0__fillcap_8
XFILLER_26_527 VDD VDD VSS VSS gf180mcu_fd_sc_mcu7t5v0__fillcap_16
XFILLER_38_387 VDD VDD VSS VSS gf180mcu_fd_sc_mcu7t5v0__fillcap_32
X_2097_ place71/Z _2097_/A2 _2097_/A3 _2098_/A3 _2099_/A2 VDD VDD VSS VSS gf180mcu_fd_sc_mcu7t5v0__nand4_1
XTAP_TAPCELL_ROW_105_1653 VDD VSS gf180mcu_fd_sc_mcu7t5v0__filltie
XFILLER_110_37 VDD VDD VSS VSS gf180mcu_fd_sc_mcu7t5v0__fillcap_8
XFILLER_22_733 VDD VDD VSS VSS gf180mcu_fd_sc_mcu7t5v0__fill_2
XPHY_EDGE_ROW_3_Right_3 VDD VSS gf180mcu_fd_sc_mcu7t5v0__endcap
XFILLER_119_142 VDD VDD VSS VSS gf180mcu_fd_sc_mcu7t5v0__fillcap_16
XFILLER_79_39 VDD VDD VSS VSS gf180mcu_fd_sc_mcu7t5v0__fillcap_16
XTAP_TAPCELL_ROW_56_1018 VDD VSS gf180mcu_fd_sc_mcu7t5v0__filltie
XTAP_TAPCELL_ROW_116_1793 VDD VSS gf180mcu_fd_sc_mcu7t5v0__filltie
XFILLER_131_874 VDD VDD VSS VSS gf180mcu_fd_sc_mcu7t5v0__fillcap_4
XFILLER_77_928 VDD VDD VSS VSS gf180mcu_fd_sc_mcu7t5v0__fillcap_4
XFILLER_28_43 VDD VDD VSS VSS gf180mcu_fd_sc_mcu7t5v0__fill_1
XFILLER_28_98 VDD VDD VSS VSS gf180mcu_fd_sc_mcu7t5v0__fillcap_4
XFILLER_44_302 VDD VDD VSS VSS gf180mcu_fd_sc_mcu7t5v0__fill_1
XFILLER_57_696 VDD VDD VSS VSS gf180mcu_fd_sc_mcu7t5v0__fillcap_4
XTAP_TAPCELL_ROW_67_1158 VDD VSS gf180mcu_fd_sc_mcu7t5v0__filltie
XFILLER_71_154 VDD VDD VSS VSS gf180mcu_fd_sc_mcu7t5v0__fill_2
XTAP_TAPCELL_ROW_80_1325 VDD VSS gf180mcu_fd_sc_mcu7t5v0__filltie
XFILLER_13_766 VDD VDD VSS VSS gf180mcu_fd_sc_mcu7t5v0__fillcap_4
XFILLER_9_759 VDD VDD VSS VSS gf180mcu_fd_sc_mcu7t5v0__fillcap_8
XTAP_TAPCELL_ROW_10_422 VDD VSS gf180mcu_fd_sc_mcu7t5v0__filltie
XTAP_TAPCELL_ROW_10_411 VDD VSS gf180mcu_fd_sc_mcu7t5v0__filltie
XFILLER_5_932 VDD VDD VSS VSS gf180mcu_fd_sc_mcu7t5v0__fill_2
XFILLER_113_329 VDD VDD VSS VSS gf180mcu_fd_sc_mcu7t5v0__fillcap_16
XTAP_TAPCELL_ROW_78_1298 VDD VSS gf180mcu_fd_sc_mcu7t5v0__filltie
XFILLER_4_453 VDD VDD VSS VSS gf180mcu_fd_sc_mcu7t5v0__fill_2
XFILLER_4_475 VDD VDD VSS VSS gf180mcu_fd_sc_mcu7t5v0__fill_1
XTAP_TAPCELL_ROW_91_1465 VDD VSS gf180mcu_fd_sc_mcu7t5v0__filltie
XFILLER_69_72 VDD VDD VSS VSS gf180mcu_fd_sc_mcu7t5v0__fillcap_64
XFILLER_94_202 VDD VDD VSS VSS gf180mcu_fd_sc_mcu7t5v0__fill_1
X_2020_ _2097_/A2 _2097_/A3 _2021_/A2 _2022_/A2 VDD VDD VSS VSS gf180mcu_fd_sc_mcu7t5v0__nand3_2
XFILLER_91_931 VDD VDD VSS VSS gf180mcu_fd_sc_mcu7t5v0__fill_2
XTAP_TAPCELL_ROW_18_522 VDD VSS gf180mcu_fd_sc_mcu7t5v0__filltie
X_3971_ _3971_/D _2279_/I _4128_/CLK _3971_/Q VDD VDD VSS VSS gf180mcu_fd_sc_mcu7t5v0__dffrnq_1
XFILLER_90_474 VDD VDD VSS VSS gf180mcu_fd_sc_mcu7t5v0__fillcap_32
XTAP_TAPCELL_ROW_46_886 VDD VSS gf180mcu_fd_sc_mcu7t5v0__filltie
XFILLER_63_699 VDD VDD VSS VSS gf180mcu_fd_sc_mcu7t5v0__fill_1
X_2922_ place83/Z _3908_/Q _2972_/S _3908_/D VDD VDD VSS VSS gf180mcu_fd_sc_mcu7t5v0__mux2_2
XFILLER_31_552 VDD VDD VSS VSS gf180mcu_fd_sc_mcu7t5v0__fill_1
X_2853_ place90/Z _3877_/Q _2867_/S _3877_/D VDD VDD VSS VSS gf180mcu_fd_sc_mcu7t5v0__mux2_2
XFILLER_129_440 VDD VDD VSS VSS gf180mcu_fd_sc_mcu7t5v0__fill_2
XTAP_TAPCELL_ROW_100_1583 VDD VSS gf180mcu_fd_sc_mcu7t5v0__filltie
X_1804_ _3887_/Q _3888_/Q _3886_/Q _2013_/A3 VDD VDD VSS VSS gf180mcu_fd_sc_mcu7t5v0__nor3_1
X_2784_ _2852_/A2 _2818_/A2 _2799_/S VDD VDD VSS VSS gf180mcu_fd_sc_mcu7t5v0__nand2_4
XFILLER_129_484 VDD VDD VSS VSS gf180mcu_fd_sc_mcu7t5v0__fillcap_4
XFILLER_116_101 VDD VDD VSS VSS gf180mcu_fd_sc_mcu7t5v0__fillcap_4
Xhold214 s_axi_wdata[19] hold214/Z VDD VDD VSS VSS gf180mcu_fd_sc_mcu7t5v0__dlyc_1
Xhold225 s_axi_wdata[13] hold225/Z VDD VDD VSS VSS gf180mcu_fd_sc_mcu7t5v0__dlyc_1
Xhold203 s_axi_wdata[6] hold203/Z VDD VDD VSS VSS gf180mcu_fd_sc_mcu7t5v0__dlyc_1
X_3405_ _4094_/Q _3405_/A2 _4094_/D VDD VDD VSS VSS gf180mcu_fd_sc_mcu7t5v0__xnor2_1
X_3336_ _4077_/Q _3337_/B2 VDD VDD VSS VSS gf180mcu_fd_sc_mcu7t5v0__clkinv_1
XFILLER_59_928 VDD VDD VSS VSS gf180mcu_fd_sc_mcu7t5v0__fillcap_4
XFILLER_98_585 VDD VDD VSS VSS gf180mcu_fd_sc_mcu7t5v0__fillcap_8
XFILLER_85_224 VDD VDD VSS VSS gf180mcu_fd_sc_mcu7t5v0__fill_2
XPHY_EDGE_ROW_0_Left_133 VDD VSS gf180mcu_fd_sc_mcu7t5v0__endcap
XFILLER_58_427 VDD VDD VSS VSS gf180mcu_fd_sc_mcu7t5v0__fill_2
XFILLER_74_909 VDD VDD VSS VSS gf180mcu_fd_sc_mcu7t5v0__fillcap_16
X_3267_ _4063_/Q _3626_/A1 VDD VDD VSS VSS gf180mcu_fd_sc_mcu7t5v0__clkinv_1
Xload_slew183 _4157_/RN _2279_/I VDD VDD VSS VSS gf180mcu_fd_sc_mcu7t5v0__buf_20
X_3198_ _4038_/Q _4006_/Q _4129_/D _4038_/D VDD VDD VSS VSS gf180mcu_fd_sc_mcu7t5v0__mux2_2
X_2218_ _2112_/I _4115_/Q _4090_/Q _2219_/C VDD VDD VSS VSS gf180mcu_fd_sc_mcu7t5v0__nor3_1
XFILLER_27_836 VDD VDD VSS VSS gf180mcu_fd_sc_mcu7t5v0__fillcap_4
XFILLER_38_162 VDD VDD VSS VSS gf180mcu_fd_sc_mcu7t5v0__fillcap_8
XFILLER_39_696 VDD VDD VSS VSS gf180mcu_fd_sc_mcu7t5v0__fillcap_4
XFILLER_121_14 VDD VDD VSS VSS gf180mcu_fd_sc_mcu7t5v0__fill_2
X_2149_ _4089_/Q _3390_/A1 VDD VDD VSS VSS gf180mcu_fd_sc_mcu7t5v0__clkinv_1
XFILLER_121_58 VDD VDD VSS VSS gf180mcu_fd_sc_mcu7t5v0__fillcap_8
XFILLER_81_18 VDD VDD VSS VSS gf180mcu_fd_sc_mcu7t5v0__fillcap_8
XFILLER_26_368 VDD VDD VSS VSS gf180mcu_fd_sc_mcu7t5v0__fill_2
XFILLER_42_839 VDD VDD VSS VSS gf180mcu_fd_sc_mcu7t5v0__fillcap_4
XFILLER_10_714 VDD VDD VSS VSS gf180mcu_fd_sc_mcu7t5v0__fillcap_16
XFILLER_22_563 VDD VDD VSS VSS gf180mcu_fd_sc_mcu7t5v0__fillcap_4
XPHY_EDGE_ROW_46_Left_179 VDD VSS gf180mcu_fd_sc_mcu7t5v0__endcap
XTAP_TAPCELL_ROW_62_1088 VDD VSS gf180mcu_fd_sc_mcu7t5v0__filltie
XTAP_TAPCELL_ROW_118_1822 VDD VSS gf180mcu_fd_sc_mcu7t5v0__filltie
XFILLER_39_20 VDD VDD VSS VSS gf180mcu_fd_sc_mcu7t5v0__fill_1
XFILLER_49_416 VDD VDD VSS VSS gf180mcu_fd_sc_mcu7t5v0__fillcap_4
XPHY_EDGE_ROW_55_Left_188 VDD VSS gf180mcu_fd_sc_mcu7t5v0__endcap
XFILLER_77_769 VDD VDD VSS VSS gf180mcu_fd_sc_mcu7t5v0__fill_1
XTAP_TAPCELL_ROW_129_1962 VDD VSS gf180mcu_fd_sc_mcu7t5v0__filltie
XFILLER_64_419 VDD VDD VSS VSS gf180mcu_fd_sc_mcu7t5v0__fillcap_32
XFILLER_17_346 VDD VDD VSS VSS gf180mcu_fd_sc_mcu7t5v0__fillcap_4
XFILLER_57_482 VDD VDD VSS VSS gf180mcu_fd_sc_mcu7t5v0__fillcap_8
XFILLER_13_552 VDD VDD VSS VSS gf180mcu_fd_sc_mcu7t5v0__fillcap_8
XTAP_TAPCELL_ROW_43_845 VDD VSS gf180mcu_fd_sc_mcu7t5v0__filltie
XPHY_EDGE_ROW_64_Left_197 VDD VSS gf180mcu_fd_sc_mcu7t5v0__endcap
XFILLER_41_894 VDD VDD VSS VSS gf180mcu_fd_sc_mcu7t5v0__fill_1
XTAP_TAPCELL_ROW_23_580 VDD VSS gf180mcu_fd_sc_mcu7t5v0__filltie
XTAP_TAPCELL_ROW_23_591 VDD VSS gf180mcu_fd_sc_mcu7t5v0__filltie
XFILLER_126_465 VDD VDD VSS VSS gf180mcu_fd_sc_mcu7t5v0__fillcap_4
XFILLER_113_126 VDD VDD VSS VSS gf180mcu_fd_sc_mcu7t5v0__fillcap_8
XFILLER_99_338 VDD VDD VSS VSS gf180mcu_fd_sc_mcu7t5v0__fillcap_8
XFILLER_122_660 VDD VDD VSS VSS gf180mcu_fd_sc_mcu7t5v0__fillcap_4
X_3121_ _4001_/Q _3121_/I1 _3160_/S _4001_/D VDD VDD VSS VSS gf180mcu_fd_sc_mcu7t5v0__mux2_2
XFILLER_110_877 VDD VDD VSS VSS gf180mcu_fd_sc_mcu7t5v0__fillcap_4
X_3052_ _4048_/Q _3968_/Q _3081_/S _3968_/D VDD VDD VSS VSS gf180mcu_fd_sc_mcu7t5v0__mux2_2
XFILLER_36_611 VDD VDD VSS VSS gf180mcu_fd_sc_mcu7t5v0__fill_1
XFILLER_67_279 VDD VDD VSS VSS gf180mcu_fd_sc_mcu7t5v0__fill_1
X_2003_ _3519_/A1 _3043_/A2 _2007_/A2 VDD VDD VSS VSS gf180mcu_fd_sc_mcu7t5v0__nor2_1
XFILLER_64_931 VDD VDD VSS VSS gf180mcu_fd_sc_mcu7t5v0__fill_2
XFILLER_91_772 VDD VDD VSS VSS gf180mcu_fd_sc_mcu7t5v0__fill_2
XFILLER_51_603 VDD VDD VSS VSS gf180mcu_fd_sc_mcu7t5v0__fillcap_16
XTAP_TAPCELL_ROW_102_1612 VDD VSS gf180mcu_fd_sc_mcu7t5v0__filltie
XFILLER_35_187 VDD VDD VSS VSS gf180mcu_fd_sc_mcu7t5v0__fill_2
X_3954_ _3954_/D _2279_/I _4125_/CLK _3954_/Q VDD VDD VSS VSS gf180mcu_fd_sc_mcu7t5v0__dffrnq_1
X_2905_ _2905_/A1 _2900_/S _2905_/B _3900_/D VDD VDD VSS VSS gf180mcu_fd_sc_mcu7t5v0__oai21_1
X_3885_ _3885_/D _4148_/RN _4057_/CLK _3885_/Q VDD VDD VSS VSS gf180mcu_fd_sc_mcu7t5v0__dffsnq_1
XFILLER_32_872 VDD VDD VSS VSS gf180mcu_fd_sc_mcu7t5v0__fill_2
X_2836_ place90/Z _3869_/Q _2850_/S _3869_/D VDD VDD VSS VSS gf180mcu_fd_sc_mcu7t5v0__mux2_2
XFILLER_129_270 VDD VDD VSS VSS gf180mcu_fd_sc_mcu7t5v0__fill_2
X_2767_ _2835_/A1 _2818_/A2 _2782_/S VDD VDD VSS VSS gf180mcu_fd_sc_mcu7t5v0__nand2_4
XFILLER_104_104 VDD VDD VSS VSS gf180mcu_fd_sc_mcu7t5v0__fill_1
X_2698_ place89/Z _3806_/Q _2710_/S _3806_/D VDD VDD VSS VSS gf180mcu_fd_sc_mcu7t5v0__mux2_2
XFILLER_105_649 VDD VDD VSS VSS gf180mcu_fd_sc_mcu7t5v0__fill_1
XFILLER_104_115 VDD VDD VSS VSS gf180mcu_fd_sc_mcu7t5v0__fill_1
XTAP_TAPCELL_ROW_113_1752 VDD VSS gf180mcu_fd_sc_mcu7t5v0__filltie
XFILLER_101_822 VDD VDD VSS VSS gf180mcu_fd_sc_mcu7t5v0__fillcap_16
XFILLER_98_382 VDD VDD VSS VSS gf180mcu_fd_sc_mcu7t5v0__fill_2
X_3319_ _3353_/B _4148_/Q _3319_/B _3319_/C _3320_/B VDD VDD VSS VSS gf180mcu_fd_sc_mcu7t5v0__oai211_1
XFILLER_100_387 VDD VDD VSS VSS gf180mcu_fd_sc_mcu7t5v0__fillcap_64
XFILLER_100_376 VDD VDD VSS VSS gf180mcu_fd_sc_mcu7t5v0__fillcap_8
XFILLER_46_419 VDD VDD VSS VSS gf180mcu_fd_sc_mcu7t5v0__fillcap_16
XFILLER_82_761 VDD VDD VSS VSS gf180mcu_fd_sc_mcu7t5v0__fillcap_4
XFILLER_81_282 VDD VDD VSS VSS gf180mcu_fd_sc_mcu7t5v0__fill_2
XFILLER_81_260 VDD VDD VSS VSS gf180mcu_fd_sc_mcu7t5v0__fillcap_16
XFILLER_15_839 VDD VDD VSS VSS gf180mcu_fd_sc_mcu7t5v0__fill_1
XTAP_TAPCELL_ROW_1_297 VDD VSS gf180mcu_fd_sc_mcu7t5v0__filltie
XFILLER_27_699 VDD VDD VSS VSS gf180mcu_fd_sc_mcu7t5v0__fill_1
XTAP_TAPCELL_ROW_64_1117 VDD VSS gf180mcu_fd_sc_mcu7t5v0__filltie
XTAP_TAPCELL_ROW_124_1892 VDD VSS gf180mcu_fd_sc_mcu7t5v0__filltie
XFILLER_25_88 VDD VDD VSS VSS gf180mcu_fd_sc_mcu7t5v0__fillcap_8
XTAP_TAPCELL_ROW_40_804 VDD VSS gf180mcu_fd_sc_mcu7t5v0__filltie
XFILLER_22_393 VDD VDD VSS VSS gf180mcu_fd_sc_mcu7t5v0__fill_1
XFILLER_6_504 VDD VDD VSS VSS gf180mcu_fd_sc_mcu7t5v0__fillcap_16
XTAP_TAPCELL_ROW_20_550 VDD VSS gf180mcu_fd_sc_mcu7t5v0__filltie
XTAP_TAPCELL_ROW_75_1257 VDD VSS gf180mcu_fd_sc_mcu7t5v0__filltie
XFILLER_110_107 VDD VDD VSS VSS gf180mcu_fd_sc_mcu7t5v0__fillcap_32
XTAP_TAPCELL_ROW_9_397 VDD VSS gf180mcu_fd_sc_mcu7t5v0__filltie
XFILLER_1_275 VDD VDD VSS VSS gf180mcu_fd_sc_mcu7t5v0__fillcap_4
XFILLER_38_909 VDD VDD VSS VSS gf180mcu_fd_sc_mcu7t5v0__fillcap_16
XTAP_TAPCELL_ROW_48_904 VDD VSS gf180mcu_fd_sc_mcu7t5v0__filltie
XTAP_TAPCELL_ROW_48_915 VDD VSS gf180mcu_fd_sc_mcu7t5v0__filltie
XFILLER_46_931 VDD VDD VSS VSS gf180mcu_fd_sc_mcu7t5v0__fill_2
XFILLER_92_569 VDD VDD VSS VSS gf180mcu_fd_sc_mcu7t5v0__fill_1
XFILLER_73_772 VDD VDD VSS VSS gf180mcu_fd_sc_mcu7t5v0__fillcap_64
XTAP_TAPCELL_ROW_28_650 VDD VSS gf180mcu_fd_sc_mcu7t5v0__filltie
XPHY_EDGE_ROW_72_Left_205 VDD VSS gf180mcu_fd_sc_mcu7t5v0__endcap
X_3670_ _3670_/D _4167_/CLK _3670_/Q VDD VDD VSS VSS gf180mcu_fd_sc_mcu7t5v0__dffq_1
X_2621_ _4120_/Q _2748_/A1 VDD VDD VSS VSS gf180mcu_fd_sc_mcu7t5v0__clkinv_1
XFILLER_127_763 VDD VDD VSS VSS gf180mcu_fd_sc_mcu7t5v0__fillcap_4
XFILLER_126_240 VDD VDD VSS VSS gf180mcu_fd_sc_mcu7t5v0__fillcap_4
XFILLER_126_251 VDD VDD VSS VSS gf180mcu_fd_sc_mcu7t5v0__fill_2
XFILLER_115_903 VDD VDD VSS VSS gf180mcu_fd_sc_mcu7t5v0__fillcap_4
X_2552_ _3746_/Q place80/Z _2556_/S _3746_/D VDD VDD VSS VSS gf180mcu_fd_sc_mcu7t5v0__mux2_2
XPHY_EDGE_ROW_81_Left_214 VDD VSS gf180mcu_fd_sc_mcu7t5v0__endcap
Xoutput149 _2233_/ZN s_axi_rdata[11] VDD VDD VSS VSS gf180mcu_fd_sc_mcu7t5v0__dlyb_1
XFILLER_99_135 VDD VDD VSS VSS gf180mcu_fd_sc_mcu7t5v0__fillcap_4
XFILLER_49_2 VDD VDD VSS VSS gf180mcu_fd_sc_mcu7t5v0__fillcap_32
XFILLER_114_457 VDD VDD VSS VSS gf180mcu_fd_sc_mcu7t5v0__fillcap_32
X_2483_ _3715_/Q _4073_/Q _2485_/S _3715_/D VDD VDD VSS VSS gf180mcu_fd_sc_mcu7t5v0__mux2_2
XFILLER_95_341 VDD VDD VSS VSS gf180mcu_fd_sc_mcu7t5v0__fillcap_8
X_4153_ _4153_/D _4157_/RN _4153_/CLK _4153_/Q VDD VDD VSS VSS gf180mcu_fd_sc_mcu7t5v0__dffrnq_1
XFILLER_95_352 VDD VDD VSS VSS gf180mcu_fd_sc_mcu7t5v0__fillcap_32
X_3104_ _3993_/Q _3104_/I1 _3160_/S _3993_/D VDD VDD VSS VSS gf180mcu_fd_sc_mcu7t5v0__mux2_2
X_4084_ _4084_/D input92/Z _4163_/CLK _4084_/Q VDD VDD VSS VSS gf180mcu_fd_sc_mcu7t5v0__dffrnq_1
X_3035_ _3961_/Q _4049_/Q _3041_/S _3961_/D VDD VDD VSS VSS gf180mcu_fd_sc_mcu7t5v0__mux2_2
XFILLER_83_536 VDD VDD VSS VSS gf180mcu_fd_sc_mcu7t5v0__fillcap_16
XFILLER_55_227 VDD VDD VSS VSS gf180mcu_fd_sc_mcu7t5v0__fill_2
XFILLER_102_27 VDD VDD VSS VSS gf180mcu_fd_sc_mcu7t5v0__fillcap_8
XPHY_EDGE_ROW_90_Left_223 VDD VSS gf180mcu_fd_sc_mcu7t5v0__endcap
XFILLER_51_422 VDD VDD VSS VSS gf180mcu_fd_sc_mcu7t5v0__fillcap_8
XFILLER_63_282 VDD VDD VSS VSS gf180mcu_fd_sc_mcu7t5v0__fillcap_32
XFILLER_23_146 VDD VDD VSS VSS gf180mcu_fd_sc_mcu7t5v0__fill_2
XFILLER_24_658 VDD VDD VSS VSS gf180mcu_fd_sc_mcu7t5v0__fillcap_4
X_3937_ _3937_/D _2279_/I _4114_/CLK _3937_/Q VDD VDD VSS VSS gf180mcu_fd_sc_mcu7t5v0__dffrnq_1
XFILLER_51_488 VDD VDD VSS VSS gf180mcu_fd_sc_mcu7t5v0__fill_2
X_3868_ _3868_/D clkload8/I _3868_/Q VDD VDD VSS VSS gf180mcu_fd_sc_mcu7t5v0__dffq_1
X_2819_ place90/Z _3861_/Q _2833_/S _3861_/D VDD VDD VSS VSS gf180mcu_fd_sc_mcu7t5v0__mux2_2
X_3799_ _3799_/D _3864_/CLK _3799_/Q VDD VDD VSS VSS gf180mcu_fd_sc_mcu7t5v0__dffq_1
XFILLER_106_903 VDD VDD VSS VSS gf180mcu_fd_sc_mcu7t5v0__fillcap_16
XFILLER_121_928 VDD VDD VSS VSS gf180mcu_fd_sc_mcu7t5v0__fillcap_4
XFILLER_87_39 VDD VDD VSS VSS gf180mcu_fd_sc_mcu7t5v0__fillcap_4
XFILLER_120_405 VDD VDD VSS VSS gf180mcu_fd_sc_mcu7t5v0__fill_1
XFILLER_87_842 VDD VDD VSS VSS gf180mcu_fd_sc_mcu7t5v0__fillcap_8
XTAP_TAPCELL_ROW_6_367 VDD VSS gf180mcu_fd_sc_mcu7t5v0__filltie
XFILLER_59_555 VDD VDD VSS VSS gf180mcu_fd_sc_mcu7t5v0__fillcap_4
XPHY_EDGE_ROW_129_Left_262 VDD VSS gf180mcu_fd_sc_mcu7t5v0__endcap
XFILLER_87_886 VDD VDD VSS VSS gf180mcu_fd_sc_mcu7t5v0__fillcap_4
XFILLER_19_419 VDD VDD VSS VSS gf180mcu_fd_sc_mcu7t5v0__fill_1
XFILLER_47_728 VDD VDD VSS VSS gf180mcu_fd_sc_mcu7t5v0__fill_1
XTAP_TAPCELL_ROW_70_1198 VDD VSS gf180mcu_fd_sc_mcu7t5v0__filltie
XTAP_TAPCELL_ROW_126_1921 VDD VSS gf180mcu_fd_sc_mcu7t5v0__filltie
XFILLER_101_696 VDD VDD VSS VSS gf180mcu_fd_sc_mcu7t5v0__fillcap_4
XFILLER_27_430 VDD VDD VSS VSS gf180mcu_fd_sc_mcu7t5v0__fillcap_4
XFILLER_43_912 VDD VDD VSS VSS gf180mcu_fd_sc_mcu7t5v0__fillcap_16
XFILLER_55_772 VDD VDD VSS VSS gf180mcu_fd_sc_mcu7t5v0__fillcap_32
XFILLER_70_731 VDD VDD VSS VSS gf180mcu_fd_sc_mcu7t5v0__fillcap_4
XTAP_TAPCELL_ROW_53_973 VDD VSS gf180mcu_fd_sc_mcu7t5v0__filltie
XFILLER_11_820 VDD VDD VSS VSS gf180mcu_fd_sc_mcu7t5v0__fillcap_4
XFILLER_52_53 VDD VDD VSS VSS gf180mcu_fd_sc_mcu7t5v0__fillcap_8
XFILLER_10_341 VDD VDD VSS VSS gf180mcu_fd_sc_mcu7t5v0__fill_2
XFILLER_109_796 VDD VDD VSS VSS gf180mcu_fd_sc_mcu7t5v0__fill_1
XFILLER_124_777 VDD VDD VSS VSS gf180mcu_fd_sc_mcu7t5v0__fillcap_4
XFILLER_97_617 VDD VDD VSS VSS gf180mcu_fd_sc_mcu7t5v0__fillcap_8
XFILLER_111_438 VDD VDD VSS VSS gf180mcu_fd_sc_mcu7t5v0__fillcap_8
XFILLER_77_72 VDD VDD VSS VSS gf180mcu_fd_sc_mcu7t5v0__fillcap_32
XFILLER_77_352 VDD VDD VSS VSS gf180mcu_fd_sc_mcu7t5v0__fillcap_16
XTAP_TAPCELL_ROW_88_1426 VDD VSS gf180mcu_fd_sc_mcu7t5v0__filltie
XFILLER_37_227 VDD VDD VSS VSS gf180mcu_fd_sc_mcu7t5v0__fillcap_32
XFILLER_46_761 VDD VDD VSS VSS gf180mcu_fd_sc_mcu7t5v0__fill_2
XFILLER_33_422 VDD VDD VSS VSS gf180mcu_fd_sc_mcu7t5v0__fillcap_64
X_1983_ _4086_/Q _3385_/A2 VDD VDD VSS VSS gf180mcu_fd_sc_mcu7t5v0__clkinv_1
X_3722_ _3722_/D _3733_/CLK _3722_/Q VDD VDD VSS VSS gf180mcu_fd_sc_mcu7t5v0__dffq_1
XFILLER_119_549 VDD VDD VSS VSS gf180mcu_fd_sc_mcu7t5v0__fillcap_8
XTAP_TAPCELL_ROW_99_1577 VDD VSS gf180mcu_fd_sc_mcu7t5v0__filltie
X_3653_ _3653_/D _3749_/CLK _3653_/Q VDD VDD VSS VSS gf180mcu_fd_sc_mcu7t5v0__dffq_1
XTAP_TAPCELL_ROW_31_689 VDD VSS gf180mcu_fd_sc_mcu7t5v0__filltie
X_2604_ _2852_/A1 _2801_/A1 _2619_/S VDD VDD VSS VSS gf180mcu_fd_sc_mcu7t5v0__nand2_2
X_3584_ _3786_/Q _3794_/Q _3802_/Q _3810_/Q place76/Z place75/Z _3584_/Z VDD VDD VSS
+ VSS gf180mcu_fd_sc_mcu7t5v0__mux4_1
XFILLER_115_766 VDD VDD VSS VSS gf180mcu_fd_sc_mcu7t5v0__fillcap_4
XFILLER_103_906 VDD VDD VSS VSS gf180mcu_fd_sc_mcu7t5v0__fillcap_4
XTAP_TAPCELL_ROW_110_1722 VDD VSS gf180mcu_fd_sc_mcu7t5v0__filltie
XTAP_TAPCELL_ROW_110_1711 VDD VSS gf180mcu_fd_sc_mcu7t5v0__filltie
XFILLER_103_928 VDD VDD VSS VSS gf180mcu_fd_sc_mcu7t5v0__fillcap_4
X_2466_ _4074_/Q _3708_/Q _2466_/S _3708_/D VDD VDD VSS VSS gf180mcu_fd_sc_mcu7t5v0__mux2_2
XFILLER_130_769 VDD VDD VSS VSS gf180mcu_fd_sc_mcu7t5v0__fill_2
X_4136_ _4136_/D _4148_/RN _4136_/CLK _4136_/Q VDD VDD VSS VSS gf180mcu_fd_sc_mcu7t5v0__dffrnq_1
XFILLER_96_683 VDD VDD VSS VSS gf180mcu_fd_sc_mcu7t5v0__fill_2
XFILLER_96_661 VDD VDD VSS VSS gf180mcu_fd_sc_mcu7t5v0__fillcap_4
X_2397_ _4097_/Q _4098_/Q _2523_/A3 _2412_/S VDD VDD VSS VSS gf180mcu_fd_sc_mcu7t5v0__nand3_2
XFILLER_3_80 VDD VDD VSS VSS gf180mcu_fd_sc_mcu7t5v0__fill_1
XTAP_TAPCELL_ROW_3_326 VDD VSS gf180mcu_fd_sc_mcu7t5v0__filltie
XFILLER_68_341 VDD VDD VSS VSS gf180mcu_fd_sc_mcu7t5v0__fill_1
XFILLER_29_739 VDD VDD VSS VSS gf180mcu_fd_sc_mcu7t5v0__fill_2
XFILLER_84_889 VDD VDD VSS VSS gf180mcu_fd_sc_mcu7t5v0__fill_2
X_4067_ _4067_/D input92/Z _4166_/CLK _4067_/Q VDD VDD VSS VSS gf180mcu_fd_sc_mcu7t5v0__dffrnq_1
XTAP_TAPCELL_ROW_108_1684 VDD VSS gf180mcu_fd_sc_mcu7t5v0__filltie
XFILLER_25_912 VDD VDD VSS VSS gf180mcu_fd_sc_mcu7t5v0__fillcap_16
XTAP_TAPCELL_ROW_39_789 VDD VSS gf180mcu_fd_sc_mcu7t5v0__filltie
XTAP_TAPCELL_ROW_108_1695 VDD VSS gf180mcu_fd_sc_mcu7t5v0__filltie
XTAP_TAPCELL_ROW_121_1862 VDD VSS gf180mcu_fd_sc_mcu7t5v0__filltie
XTAP_TAPCELL_ROW_50_932 VDD VSS gf180mcu_fd_sc_mcu7t5v0__filltie
XFILLER_98_27 VDD VDD VSS VSS gf180mcu_fd_sc_mcu7t5v0__fillcap_8
XTAP_TAPCELL_ROW_59_1049 VDD VSS gf180mcu_fd_sc_mcu7t5v0__filltie
XTAP_TAPCELL_ROW_72_1216 VDD VSS gf180mcu_fd_sc_mcu7t5v0__filltie
XFILLER_121_714 VDD VDD VSS VSS gf180mcu_fd_sc_mcu7t5v0__fill_2
XFILLER_106_788 VDD VDD VSS VSS gf180mcu_fd_sc_mcu7t5v0__fillcap_16
XTAP_TAPCELL_ROW_72_1227 VDD VSS gf180mcu_fd_sc_mcu7t5v0__filltie
XFILLER_121_769 VDD VDD VSS VSS gf180mcu_fd_sc_mcu7t5v0__fill_1
XPHY_EDGE_ROW_110_Right_110 VDD VSS gf180mcu_fd_sc_mcu7t5v0__endcap
XFILLER_120_279 VDD VDD VSS VSS gf180mcu_fd_sc_mcu7t5v0__fillcap_8
XFILLER_59_352 VDD VDD VSS VSS gf180mcu_fd_sc_mcu7t5v0__fillcap_16
XFILLER_47_42 VDD VDD VSS VSS gf180mcu_fd_sc_mcu7t5v0__fill_2
XFILLER_15_422 VDD VDD VSS VSS gf180mcu_fd_sc_mcu7t5v0__fillcap_32
XFILLER_27_282 VDD VDD VSS VSS gf180mcu_fd_sc_mcu7t5v0__fillcap_16
XTAP_TAPCELL_ROW_83_1367 VDD VSS gf180mcu_fd_sc_mcu7t5v0__filltie
XFILLER_70_561 VDD VDD VSS VSS gf180mcu_fd_sc_mcu7t5v0__fillcap_32
XFILLER_128_335 VDD VDD VSS VSS gf180mcu_fd_sc_mcu7t5v0__fill_2
XFILLER_11_694 VDD VDD VSS VSS gf180mcu_fd_sc_mcu7t5v0__fillcap_4
XFILLER_7_632 VDD VDD VSS VSS gf180mcu_fd_sc_mcu7t5v0__fillcap_16
XFILLER_7_654 VDD VDD VSS VSS gf180mcu_fd_sc_mcu7t5v0__fillcap_32
XFILLER_7_698 VDD VDD VSS VSS gf180mcu_fd_sc_mcu7t5v0__fill_2
XFILLER_97_414 VDD VDD VSS VSS gf180mcu_fd_sc_mcu7t5v0__fillcap_4
X_2251_ _2251_/I _2251_/ZN VDD VDD VSS VSS gf180mcu_fd_sc_mcu7t5v0__inv_1
XFILLER_78_661 VDD VDD VSS VSS gf180mcu_fd_sc_mcu7t5v0__fillcap_4
XFILLER_66_801 VDD VDD VSS VSS gf180mcu_fd_sc_mcu7t5v0__fillcap_4
X_2182_ _4102_/Q _4103_/Q _2182_/Z VDD VDD VSS VSS gf180mcu_fd_sc_mcu7t5v0__or2_2
XFILLER_81_837 VDD VDD VSS VSS gf180mcu_fd_sc_mcu7t5v0__fill_2
XFILLER_80_325 VDD VDD VSS VSS gf180mcu_fd_sc_mcu7t5v0__fillcap_4
XFILLER_80_314 VDD VDD VSS VSS gf180mcu_fd_sc_mcu7t5v0__fill_1
XFILLER_19_772 VDD VDD VSS VSS gf180mcu_fd_sc_mcu7t5v0__fillcap_64
XFILLER_53_539 VDD VDD VSS VSS gf180mcu_fd_sc_mcu7t5v0__fillcap_8
XFILLER_18_271 VDD VDD VSS VSS gf180mcu_fd_sc_mcu7t5v0__fillcap_16
XFILLER_34_731 VDD VDD VSS VSS gf180mcu_fd_sc_mcu7t5v0__fillcap_4
XTAP_TAPCELL_ROW_36_748 VDD VSS gf180mcu_fd_sc_mcu7t5v0__filltie
XTAP_TAPCELL_ROW_36_759 VDD VSS gf180mcu_fd_sc_mcu7t5v0__filltie
XFILLER_46_591 VDD VDD VSS VSS gf180mcu_fd_sc_mcu7t5v0__fillcap_4
XFILLER_21_403 VDD VDD VSS VSS gf180mcu_fd_sc_mcu7t5v0__fillcap_16
XFILLER_34_775 VDD VDD VSS VSS gf180mcu_fd_sc_mcu7t5v0__fill_1
XFILLER_61_594 VDD VDD VSS VSS gf180mcu_fd_sc_mcu7t5v0__fillcap_8
XTAP_TAPCELL_ROW_16_494 VDD VSS gf180mcu_fd_sc_mcu7t5v0__filltie
X_1966_ _3982_/Q _3083_/A2 place70/I VDD VDD VSS VSS gf180mcu_fd_sc_mcu7t5v0__nor2_1
XFILLER_119_335 VDD VDD VSS VSS gf180mcu_fd_sc_mcu7t5v0__fillcap_8
X_3705_ _3705_/D _3729_/CLK _3705_/Q VDD VDD VSS VSS gf180mcu_fd_sc_mcu7t5v0__dffq_1
X_1897_ _1897_/A1 _1935_/A4 _1897_/A3 _1898_/B1 VDD VDD VSS VSS gf180mcu_fd_sc_mcu7t5v0__nand3_1
X_3636_ _3636_/D _3732_/CLK _3636_/Q VDD VDD VSS VSS gf180mcu_fd_sc_mcu7t5v0__dffq_1
X_3567_ _3760_/Q _3816_/Q _3824_/Q _3832_/Q _4116_/Q place75/Z _3567_/Z VDD VDD VSS
+ VSS gf180mcu_fd_sc_mcu7t5v0__mux4_1
X_3498_ _4110_/Q _2578_/Z _3500_/I _4110_/D VDD VDD VSS VSS gf180mcu_fd_sc_mcu7t5v0__xor3_1
XFILLER_124_69 VDD VDD VSS VSS gf180mcu_fd_sc_mcu7t5v0__fillcap_4
XFILLER_56_311 VDD VDD VSS VSS gf180mcu_fd_sc_mcu7t5v0__fillcap_4
XFILLER_29_558 VDD VDD VSS VSS gf180mcu_fd_sc_mcu7t5v0__fill_2
X_4119_ _4119_/D _4157_/RN _4148_/CLK _4119_/Q VDD VDD VSS VSS gf180mcu_fd_sc_mcu7t5v0__dffrnq_1
XFILLER_71_314 VDD VDD VSS VSS gf180mcu_fd_sc_mcu7t5v0__fillcap_8
XFILLER_71_347 VDD VDD VSS VSS gf180mcu_fd_sc_mcu7t5v0__fill_2
XFILLER_24_241 VDD VDD VSS VSS gf180mcu_fd_sc_mcu7t5v0__fillcap_4
XFILLER_12_425 VDD VDD VSS VSS gf180mcu_fd_sc_mcu7t5v0__fill_1
XFILLER_52_594 VDD VDD VSS VSS gf180mcu_fd_sc_mcu7t5v0__fill_1
XFILLER_12_469 VDD VDD VSS VSS gf180mcu_fd_sc_mcu7t5v0__fill_2
XFILLER_33_66 VDD VDD VSS VSS gf180mcu_fd_sc_mcu7t5v0__fillcap_4
XFILLER_8_429 VDD VDD VSS VSS gf180mcu_fd_sc_mcu7t5v0__fillcap_16
XFILLER_33_88 VDD VDD VSS VSS gf180mcu_fd_sc_mcu7t5v0__fillcap_4
XFILLER_126_839 VDD VDD VSS VSS gf180mcu_fd_sc_mcu7t5v0__fill_2
XFILLER_4_679 VDD VDD VSS VSS gf180mcu_fd_sc_mcu7t5v0__fill_1
XFILLER_48_801 VDD VDD VSS VSS gf180mcu_fd_sc_mcu7t5v0__fillcap_4
XFILLER_47_322 VDD VDD VSS VSS gf180mcu_fd_sc_mcu7t5v0__fillcap_4
XFILLER_48_823 VDD VDD VSS VSS gf180mcu_fd_sc_mcu7t5v0__fillcap_4
XFILLER_48_856 VDD VDD VSS VSS gf180mcu_fd_sc_mcu7t5v0__fillcap_16
XFILLER_74_174 VDD VDD VSS VSS gf180mcu_fd_sc_mcu7t5v0__fill_1
XFILLER_62_314 VDD VDD VSS VSS gf180mcu_fd_sc_mcu7t5v0__fill_1
XFILLER_90_667 VDD VDD VSS VSS gf180mcu_fd_sc_mcu7t5v0__fillcap_8
XFILLER_90_645 VDD VDD VSS VSS gf180mcu_fd_sc_mcu7t5v0__fillcap_4
XFILLER_28_580 VDD VDD VSS VSS gf180mcu_fd_sc_mcu7t5v0__fillcap_8
XFILLER_62_325 VDD VDD VSS VSS gf180mcu_fd_sc_mcu7t5v0__fillcap_4
XFILLER_16_775 VDD VDD VSS VSS gf180mcu_fd_sc_mcu7t5v0__fill_1
XTAP_TAPCELL_ROW_33_718 VDD VSS gf180mcu_fd_sc_mcu7t5v0__filltie
XFILLER_71_892 VDD VDD VSS VSS gf180mcu_fd_sc_mcu7t5v0__fillcap_16
XFILLER_31_734 VDD VDD VSS VSS gf180mcu_fd_sc_mcu7t5v0__fillcap_16
X_1820_ _3891_/Q _3892_/Q _3889_/Q _3890_/Q _1820_/Z VDD VDD VSS VSS gf180mcu_fd_sc_mcu7t5v0__or4_4
XFILLER_30_255 VDD VDD VSS VSS gf180mcu_fd_sc_mcu7t5v0__fill_2
XTAP_TAPCELL_ROW_13_453 VDD VSS gf180mcu_fd_sc_mcu7t5v0__filltie
XFILLER_117_839 VDD VDD VSS VSS gf180mcu_fd_sc_mcu7t5v0__fill_1
XTAP_TAPCELL_ROW_96_1536 VDD VSS gf180mcu_fd_sc_mcu7t5v0__filltie
X_3421_ _4104_/Q _3485_/A1 VDD VDD VSS VSS gf180mcu_fd_sc_mcu7t5v0__clkinv_1
X_3352_ _3906_/Q _3353_/A2 VDD VDD VSS VSS gf180mcu_fd_sc_mcu7t5v0__clkinv_1
X_2303_ _2505_/A1 _2558_/A1 place61/I VDD VDD VSS VSS gf180mcu_fd_sc_mcu7t5v0__nor2_1
XFILLER_31_2 VDD VDD VSS VSS gf180mcu_fd_sc_mcu7t5v0__fillcap_16
XFILLER_97_244 VDD VDD VSS VSS gf180mcu_fd_sc_mcu7t5v0__fillcap_16
X_3283_ _4080_/Q _3353_/B VDD VDD VSS VSS gf180mcu_fd_sc_mcu7t5v0__clkinv_1
X_2234_ _3913_/Q place72/Z _2236_/A1 VDD VDD VSS VSS gf180mcu_fd_sc_mcu7t5v0__nand2_1
X_2165_ _2152_/S _3936_/Q _2166_/B VDD VDD VSS VSS gf180mcu_fd_sc_mcu7t5v0__nand2_1
XFILLER_38_333 VDD VDD VSS VSS gf180mcu_fd_sc_mcu7t5v0__fillcap_8
XFILLER_66_664 VDD VDD VSS VSS gf180mcu_fd_sc_mcu7t5v0__fill_1
XFILLER_80_100 VDD VDD VSS VSS gf180mcu_fd_sc_mcu7t5v0__fillcap_4
XFILLER_53_314 VDD VDD VSS VSS gf180mcu_fd_sc_mcu7t5v0__fill_2
X_2096_ _4147_/Q _2096_/A2 _2098_/A3 VDD VDD VSS VSS gf180mcu_fd_sc_mcu7t5v0__xnor2_1
XFILLER_81_634 VDD VDD VSS VSS gf180mcu_fd_sc_mcu7t5v0__fill_1
XFILLER_0_70 VDD VDD VSS VSS gf180mcu_fd_sc_mcu7t5v0__fillcap_32
XFILLER_53_325 VDD VDD VSS VSS gf180mcu_fd_sc_mcu7t5v0__fillcap_16
XFILLER_54_859 VDD VDD VSS VSS gf180mcu_fd_sc_mcu7t5v0__fill_1
XTAP_TAPCELL_ROW_105_1654 VDD VSS gf180mcu_fd_sc_mcu7t5v0__filltie
XFILLER_80_155 VDD VDD VSS VSS gf180mcu_fd_sc_mcu7t5v0__fillcap_4
XFILLER_110_49 VDD VDD VSS VSS gf180mcu_fd_sc_mcu7t5v0__fill_2
XFILLER_110_27 VDD VDD VSS VSS gf180mcu_fd_sc_mcu7t5v0__fillcap_8
XFILLER_80_177 VDD VDD VSS VSS gf180mcu_fd_sc_mcu7t5v0__fillcap_16
XFILLER_22_745 VDD VDD VSS VSS gf180mcu_fd_sc_mcu7t5v0__fill_2
XFILLER_34_594 VDD VDD VSS VSS gf180mcu_fd_sc_mcu7t5v0__fill_1
XFILLER_62_892 VDD VDD VSS VSS gf180mcu_fd_sc_mcu7t5v0__fill_2
X_2998_ _3943_/Q _4031_/Q _3041_/S _3943_/D VDD VDD VSS VSS gf180mcu_fd_sc_mcu7t5v0__mux2_2
X_1949_ _1949_/A1 _1949_/A2 _1949_/B _2097_/A3 VDD VDD VSS VSS gf180mcu_fd_sc_mcu7t5v0__oai21_4
XFILLER_119_69 VDD VDD VSS VSS gf180mcu_fd_sc_mcu7t5v0__fill_1
XFILLER_107_349 VDD VDD VSS VSS gf180mcu_fd_sc_mcu7t5v0__fill_1
XTAP_TAPCELL_ROW_56_1008 VDD VSS gf180mcu_fd_sc_mcu7t5v0__filltie
XTAP_TAPCELL_ROW_56_1019 VDD VSS gf180mcu_fd_sc_mcu7t5v0__filltie
XTAP_TAPCELL_ROW_116_1794 VDD VSS gf180mcu_fd_sc_mcu7t5v0__filltie
XFILLER_0_104 VDD VDD VSS VSS gf180mcu_fd_sc_mcu7t5v0__fillcap_32
XFILLER_88_244 VDD VDD VSS VSS gf180mcu_fd_sc_mcu7t5v0__fill_1
XFILLER_84_461 VDD VDD VSS VSS gf180mcu_fd_sc_mcu7t5v0__fill_2
XFILLER_44_10 VDD VDD VSS VSS gf180mcu_fd_sc_mcu7t5v0__fill_2
XFILLER_44_325 VDD VDD VSS VSS gf180mcu_fd_sc_mcu7t5v0__fill_1
XFILLER_72_667 VDD VDD VSS VSS gf180mcu_fd_sc_mcu7t5v0__fillcap_64
XFILLER_60_807 VDD VDD VSS VSS gf180mcu_fd_sc_mcu7t5v0__fillcap_4
XTAP_TAPCELL_ROW_67_1159 VDD VSS gf180mcu_fd_sc_mcu7t5v0__filltie
XTAP_TAPCELL_ROW_80_1326 VDD VSS gf180mcu_fd_sc_mcu7t5v0__filltie
XFILLER_25_572 VDD VDD VSS VSS gf180mcu_fd_sc_mcu7t5v0__fillcap_32
XFILLER_71_188 VDD VDD VSS VSS gf180mcu_fd_sc_mcu7t5v0__fillcap_4
XFILLER_44_98 VDD VDD VSS VSS gf180mcu_fd_sc_mcu7t5v0__fillcap_4
XFILLER_40_597 VDD VDD VSS VSS gf180mcu_fd_sc_mcu7t5v0__fillcap_64
XTAP_TAPCELL_ROW_10_412 VDD VSS gf180mcu_fd_sc_mcu7t5v0__filltie
XFILLER_126_647 VDD VDD VSS VSS gf180mcu_fd_sc_mcu7t5v0__fill_2
XTAP_TAPCELL_ROW_78_1299 VDD VSS gf180mcu_fd_sc_mcu7t5v0__filltie
XFILLER_69_51 VDD VDD VSS VSS gf180mcu_fd_sc_mcu7t5v0__fill_2
XFILLER_121_352 VDD VDD VSS VSS gf180mcu_fd_sc_mcu7t5v0__fillcap_8
XFILLER_121_330 VDD VDD VSS VSS gf180mcu_fd_sc_mcu7t5v0__fillcap_8
XTAP_TAPCELL_ROW_91_1466 VDD VSS gf180mcu_fd_sc_mcu7t5v0__filltie
XFILLER_0_682 VDD VDD VSS VSS gf180mcu_fd_sc_mcu7t5v0__fillcap_32
XFILLER_94_247 VDD VDD VSS VSS gf180mcu_fd_sc_mcu7t5v0__fillcap_16
XPHY_EDGE_ROW_13_Right_13 VDD VSS gf180mcu_fd_sc_mcu7t5v0__endcap
XFILLER_36_804 VDD VDD VSS VSS gf180mcu_fd_sc_mcu7t5v0__fill_1
XFILLER_85_72 VDD VDD VSS VSS gf180mcu_fd_sc_mcu7t5v0__fillcap_64
XFILLER_35_314 VDD VDD VSS VSS gf180mcu_fd_sc_mcu7t5v0__fillcap_16
XTAP_TAPCELL_ROW_18_523 VDD VSS gf180mcu_fd_sc_mcu7t5v0__filltie
X_3970_ _3970_/D _2279_/I _4128_/CLK _3970_/Q VDD VDD VSS VSS gf180mcu_fd_sc_mcu7t5v0__dffrnq_1
XFILLER_16_561 VDD VDD VSS VSS gf180mcu_fd_sc_mcu7t5v0__fill_2
XFILLER_16_583 VDD VDD VSS VSS gf180mcu_fd_sc_mcu7t5v0__fillcap_8
XTAP_TAPCELL_ROW_46_887 VDD VSS gf180mcu_fd_sc_mcu7t5v0__filltie
XFILLER_62_177 VDD VDD VSS VSS gf180mcu_fd_sc_mcu7t5v0__fillcap_64
X_2852_ _2852_/A1 _2852_/A2 _2867_/S VDD VDD VSS VSS gf180mcu_fd_sc_mcu7t5v0__nand2_2
X_1803_ _1935_/A1 _1935_/A2 _1803_/Z VDD VDD VSS VSS gf180mcu_fd_sc_mcu7t5v0__and2_1
XTAP_TAPCELL_ROW_100_1584 VDD VSS gf180mcu_fd_sc_mcu7t5v0__filltie
XFILLER_79_2 VDD VDD VSS VSS gf180mcu_fd_sc_mcu7t5v0__fill_2
XPHY_EDGE_ROW_22_Right_22 VDD VSS gf180mcu_fd_sc_mcu7t5v0__endcap
Xhold215 s_axi_bready hold215/Z VDD VDD VSS VSS gf180mcu_fd_sc_mcu7t5v0__dlyc_1
Xhold204 s_axi_wdata[24] hold204/Z VDD VDD VSS VSS gf180mcu_fd_sc_mcu7t5v0__dlyc_1
Xhold226 s_axi_wdata[4] hold226/Z VDD VDD VSS VSS gf180mcu_fd_sc_mcu7t5v0__dlyc_1
X_3404_ place78/Z place79/Z _4093_/Q _3372_/Z _3405_/A2 VDD VDD VSS VSS gf180mcu_fd_sc_mcu7t5v0__nand4_1
XFILLER_131_127 VDD VDD VSS VSS gf180mcu_fd_sc_mcu7t5v0__fillcap_8
XFILLER_113_842 VDD VDD VSS VSS gf180mcu_fd_sc_mcu7t5v0__fillcap_64
X_3335_ _3316_/Z _3337_/A2 _3335_/B _3337_/B1 VDD VDD VSS VSS gf180mcu_fd_sc_mcu7t5v0__oai21_1
XFILLER_59_907 VDD VDD VSS VSS gf180mcu_fd_sc_mcu7t5v0__fill_2
XFILLER_98_597 VDD VDD VSS VSS gf180mcu_fd_sc_mcu7t5v0__fillcap_4
XFILLER_86_737 VDD VDD VSS VSS gf180mcu_fd_sc_mcu7t5v0__fillcap_64
X_3266_ _3266_/I _4062_/D VDD VDD VSS VSS gf180mcu_fd_sc_mcu7t5v0__inv_1
XPHY_EDGE_ROW_31_Right_31 VDD VSS gf180mcu_fd_sc_mcu7t5v0__endcap
XFILLER_39_620 VDD VDD VSS VSS gf180mcu_fd_sc_mcu7t5v0__fillcap_8
X_2217_ _2217_/A1 _2217_/A2 _2217_/A3 _2217_/ZN VDD VDD VSS VSS gf180mcu_fd_sc_mcu7t5v0__nand3_1
Xload_slew184 input92/Z _4157_/RN VDD VDD VSS VSS gf180mcu_fd_sc_mcu7t5v0__buf_20
XFILLER_38_130 VDD VDD VSS VSS gf180mcu_fd_sc_mcu7t5v0__fill_2
X_2148_ _3375_/A2 _2147_/Z _2156_/A1 VDD VDD VSS VSS gf180mcu_fd_sc_mcu7t5v0__nand2_1
XFILLER_38_174 VDD VDD VSS VSS gf180mcu_fd_sc_mcu7t5v0__fill_1
X_2079_ _2079_/A1 _2079_/A2 _2079_/A3 _2079_/A4 _2079_/Z VDD VDD VSS VSS gf180mcu_fd_sc_mcu7t5v0__or4_1
XFILLER_42_807 VDD VDD VSS VSS gf180mcu_fd_sc_mcu7t5v0__fillcap_32
XFILLER_81_486 VDD VDD VSS VSS gf180mcu_fd_sc_mcu7t5v0__fillcap_4
XPHY_EDGE_ROW_40_Right_40 VDD VSS gf180mcu_fd_sc_mcu7t5v0__endcap
XPHY_EDGE_ROW_101_Left_234 VDD VSS gf180mcu_fd_sc_mcu7t5v0__endcap
XFILLER_10_737 VDD VDD VSS VSS gf180mcu_fd_sc_mcu7t5v0__fillcap_8
XTAP_TAPCELL_ROW_62_1089 VDD VSS gf180mcu_fd_sc_mcu7t5v0__filltie
XTAP_TAPCELL_ROW_118_1823 VDD VSS gf180mcu_fd_sc_mcu7t5v0__filltie
XFILLER_108_669 VDD VDD VSS VSS gf180mcu_fd_sc_mcu7t5v0__fill_1
XFILLER_2_925 VDD VDD VSS VSS gf180mcu_fd_sc_mcu7t5v0__fillcap_8
XFILLER_30_89 VDD VDD VSS VSS gf180mcu_fd_sc_mcu7t5v0__fill_1
XFILLER_103_352 VDD VDD VSS VSS gf180mcu_fd_sc_mcu7t5v0__fillcap_16
XFILLER_103_330 VDD VDD VSS VSS gf180mcu_fd_sc_mcu7t5v0__fill_1
XPHY_EDGE_ROW_110_Left_243 VDD VSS gf180mcu_fd_sc_mcu7t5v0__endcap
XFILLER_39_65 VDD VDD VSS VSS gf180mcu_fd_sc_mcu7t5v0__fillcap_4
XFILLER_130_193 VDD VDD VSS VSS gf180mcu_fd_sc_mcu7t5v0__fill_2
XFILLER_76_247 VDD VDD VSS VSS gf180mcu_fd_sc_mcu7t5v0__fillcap_64
XTAP_TAPCELL_ROW_129_1963 VDD VSS gf180mcu_fd_sc_mcu7t5v0__filltie
XFILLER_91_206 VDD VDD VSS VSS gf180mcu_fd_sc_mcu7t5v0__fillcap_4
XFILLER_18_804 VDD VDD VSS VSS gf180mcu_fd_sc_mcu7t5v0__fill_1
XFILLER_73_932 VDD VDD VSS VSS gf180mcu_fd_sc_mcu7t5v0__fill_2
XFILLER_44_155 VDD VDD VSS VSS gf180mcu_fd_sc_mcu7t5v0__fill_2
XFILLER_44_177 VDD VDD VSS VSS gf180mcu_fd_sc_mcu7t5v0__fillcap_16
XFILLER_41_862 VDD VDD VSS VSS gf180mcu_fd_sc_mcu7t5v0__fill_2
XTAP_TAPCELL_ROW_43_846 VDD VSS gf180mcu_fd_sc_mcu7t5v0__filltie
XFILLER_9_524 VDD VDD VSS VSS gf180mcu_fd_sc_mcu7t5v0__fillcap_8
XFILLER_9_557 VDD VDD VSS VSS gf180mcu_fd_sc_mcu7t5v0__fill_2
XTAP_TAPCELL_ROW_23_581 VDD VSS gf180mcu_fd_sc_mcu7t5v0__filltie
XFILLER_127_912 VDD VDD VSS VSS gf180mcu_fd_sc_mcu7t5v0__fillcap_16
XFILLER_113_138 VDD VDD VSS VSS gf180mcu_fd_sc_mcu7t5v0__fill_2
XFILLER_110_801 VDD VDD VSS VSS gf180mcu_fd_sc_mcu7t5v0__fillcap_4
XFILLER_106_190 VDD VDD VSS VSS gf180mcu_fd_sc_mcu7t5v0__fillcap_32
XFILLER_68_737 VDD VDD VSS VSS gf180mcu_fd_sc_mcu7t5v0__fillcap_16
XFILLER_95_556 VDD VDD VSS VSS gf180mcu_fd_sc_mcu7t5v0__fillcap_4
XFILLER_67_236 VDD VDD VSS VSS gf180mcu_fd_sc_mcu7t5v0__fillcap_4
XFILLER_67_269 VDD VDD VSS VSS gf180mcu_fd_sc_mcu7t5v0__fillcap_8
XFILLER_82_239 VDD VDD VSS VSS gf180mcu_fd_sc_mcu7t5v0__fill_1
X_2002_ _3234_/A1 _4057_/Q _3519_/A2 _3043_/A2 VDD VDD VSS VSS gf180mcu_fd_sc_mcu7t5v0__nand3_1
XFILLER_36_667 VDD VDD VSS VSS gf180mcu_fd_sc_mcu7t5v0__fillcap_16
XTAP_TAPCELL_ROW_102_1613 VDD VSS gf180mcu_fd_sc_mcu7t5v0__filltie
XFILLER_50_103 VDD VDD VSS VSS gf180mcu_fd_sc_mcu7t5v0__fill_2
X_3953_ _3953_/D _2279_/I _3978_/CLK _3953_/Q VDD VDD VSS VSS gf180mcu_fd_sc_mcu7t5v0__dffrnq_1
X_2904_ _4036_/Q _2900_/S _2905_/B VDD VDD VSS VSS gf180mcu_fd_sc_mcu7t5v0__nand2_1
X_3884_ _3884_/D _4023_/CLK _3884_/Q VDD VDD VSS VSS gf180mcu_fd_sc_mcu7t5v0__dffq_1
X_2835_ _2835_/A1 _2852_/A1 _2850_/S VDD VDD VSS VSS gf180mcu_fd_sc_mcu7t5v0__nand2_2
XFILLER_117_422 VDD VDD VSS VSS gf180mcu_fd_sc_mcu7t5v0__fillcap_8
XFILLER_8_590 VDD VDD VSS VSS gf180mcu_fd_sc_mcu7t5v0__fillcap_4
X_2766_ _3540_/A1 _4123_/Q _2766_/A3 _2818_/A2 VDD VDD VSS VSS gf180mcu_fd_sc_mcu7t5v0__nor3_4
XFILLER_116_37 VDD VDD VSS VSS gf180mcu_fd_sc_mcu7t5v0__fillcap_64
XTAP_TAPCELL_ROW_113_1753 VDD VSS gf180mcu_fd_sc_mcu7t5v0__filltie
X_3318_ _3353_/B _4158_/Q _3319_/C VDD VDD VSS VSS gf180mcu_fd_sc_mcu7t5v0__nand2_1
XFILLER_59_748 VDD VDD VSS VSS gf180mcu_fd_sc_mcu7t5v0__fillcap_4
XFILLER_112_171 VDD VDD VSS VSS gf180mcu_fd_sc_mcu7t5v0__fillcap_4
XFILLER_58_247 VDD VDD VSS VSS gf180mcu_fd_sc_mcu7t5v0__fillcap_16
X_3249_ _3249_/A1 _3249_/A2 _3249_/B _4061_/D VDD VDD VSS VSS gf180mcu_fd_sc_mcu7t5v0__aoi21_1
XFILLER_26_111 VDD VDD VSS VSS gf180mcu_fd_sc_mcu7t5v0__fill_1
XFILLER_55_932 VDD VDD VSS VSS gf180mcu_fd_sc_mcu7t5v0__fill_2
XFILLER_27_656 VDD VDD VSS VSS gf180mcu_fd_sc_mcu7t5v0__fillcap_4
XFILLER_14_317 VDD VDD VSS VSS gf180mcu_fd_sc_mcu7t5v0__fillcap_64
XTAP_TAPCELL_ROW_1_298 VDD VSS gf180mcu_fd_sc_mcu7t5v0__filltie
XFILLER_26_177 VDD VDD VSS VSS gf180mcu_fd_sc_mcu7t5v0__fillcap_32
XFILLER_27_689 VDD VDD VSS VSS gf180mcu_fd_sc_mcu7t5v0__fillcap_8
XTAP_TAPCELL_ROW_64_1118 VDD VSS gf180mcu_fd_sc_mcu7t5v0__filltie
XTAP_TAPCELL_ROW_124_1893 VDD VSS gf180mcu_fd_sc_mcu7t5v0__filltie
XFILLER_23_862 VDD VDD VSS VSS gf180mcu_fd_sc_mcu7t5v0__fill_2
XTAP_TAPCELL_ROW_40_805 VDD VSS gf180mcu_fd_sc_mcu7t5v0__filltie
XFILLER_41_158 VDD VDD VSS VSS gf180mcu_fd_sc_mcu7t5v0__fillcap_4
XFILLER_109_912 VDD VDD VSS VSS gf180mcu_fd_sc_mcu7t5v0__fillcap_16
XFILLER_6_527 VDD VDD VSS VSS gf180mcu_fd_sc_mcu7t5v0__fillcap_8
XTAP_TAPCELL_ROW_20_540 VDD VSS gf180mcu_fd_sc_mcu7t5v0__filltie
XTAP_TAPCELL_ROW_20_551 VDD VSS gf180mcu_fd_sc_mcu7t5v0__filltie
XFILLER_41_66 VDD VDD VSS VSS gf180mcu_fd_sc_mcu7t5v0__fillcap_4
XFILLER_123_414 VDD VDD VSS VSS gf180mcu_fd_sc_mcu7t5v0__fillcap_4
XTAP_TAPCELL_ROW_75_1258 VDD VSS gf180mcu_fd_sc_mcu7t5v0__filltie
XFILLER_9_2 VDD VDD VSS VSS gf180mcu_fd_sc_mcu7t5v0__fill_2
XFILLER_2_722 VDD VDD VSS VSS gf180mcu_fd_sc_mcu7t5v0__fillcap_8
XTAP_TAPCELL_ROW_9_398 VDD VSS gf180mcu_fd_sc_mcu7t5v0__filltie
XFILLER_2_27 VDD VDD VSS VSS gf180mcu_fd_sc_mcu7t5v0__fillcap_8
XFILLER_92_515 VDD VDD VSS VSS gf180mcu_fd_sc_mcu7t5v0__fill_2
XTAP_TAPCELL_ROW_48_905 VDD VSS gf180mcu_fd_sc_mcu7t5v0__filltie
XTAP_TAPCELL_ROW_48_916 VDD VSS gf180mcu_fd_sc_mcu7t5v0__filltie
XFILLER_66_52 VDD VDD VSS VSS gf180mcu_fd_sc_mcu7t5v0__fillcap_16
XFILLER_92_548 VDD VDD VSS VSS gf180mcu_fd_sc_mcu7t5v0__fillcap_4
XFILLER_18_667 VDD VDD VSS VSS gf180mcu_fd_sc_mcu7t5v0__fillcap_16
XFILLER_17_122 VDD VDD VSS VSS gf180mcu_fd_sc_mcu7t5v0__fill_1
XTAP_TAPCELL_ROW_28_651 VDD VSS gf180mcu_fd_sc_mcu7t5v0__filltie
XTAP_TAPCELL_ROW_86_1398 VDD VSS gf180mcu_fd_sc_mcu7t5v0__filltie
XFILLER_45_475 VDD VDD VSS VSS gf180mcu_fd_sc_mcu7t5v0__fill_1
XFILLER_82_84 VDD VDD VSS VSS gf180mcu_fd_sc_mcu7t5v0__fillcap_16
XFILLER_60_434 VDD VDD VSS VSS gf180mcu_fd_sc_mcu7t5v0__fillcap_16
XFILLER_14_873 VDD VDD VSS VSS gf180mcu_fd_sc_mcu7t5v0__fill_2
XFILLER_60_467 VDD VDD VSS VSS gf180mcu_fd_sc_mcu7t5v0__fill_1
XPHY_EDGE_ROW_124_Right_124 VDD VSS gf180mcu_fd_sc_mcu7t5v0__endcap
XFILLER_68_512 VDD VDD VSS VSS gf180mcu_fd_sc_mcu7t5v0__fillcap_8
X_4152_ _4152_/D _4157_/RN _4156_/CLK _4152_/Q VDD VDD VSS VSS gf180mcu_fd_sc_mcu7t5v0__dffrnq_1
X_4083_ _4083_/D input92/Z _4159_/CLK _4083_/Q VDD VDD VSS VSS gf180mcu_fd_sc_mcu7t5v0__dffrnq_1
XFILLER_55_206 VDD VDD VSS VSS gf180mcu_fd_sc_mcu7t5v0__fillcap_4
XFILLER_68_567 VDD VDD VSS VSS gf180mcu_fd_sc_mcu7t5v0__fill_1
XFILLER_37_932 VDD VDD VSS VSS gf180mcu_fd_sc_mcu7t5v0__fill_2
XFILLER_36_453 VDD VDD VSS VSS gf180mcu_fd_sc_mcu7t5v0__fill_2
XFILLER_36_475 VDD VDD VSS VSS gf180mcu_fd_sc_mcu7t5v0__fill_1
XFILLER_51_434 VDD VDD VSS VSS gf180mcu_fd_sc_mcu7t5v0__fill_2
X_3936_ _3936_/D _4157_/RN _4127_/CLK _3936_/Q VDD VDD VSS VSS gf180mcu_fd_sc_mcu7t5v0__dffrnq_1
X_3867_ _3867_/D clkload7/I _3867_/Q VDD VDD VSS VSS gf180mcu_fd_sc_mcu7t5v0__dffq_1
X_3798_ _3798_/D _3806_/CLK _3798_/Q VDD VDD VSS VSS gf180mcu_fd_sc_mcu7t5v0__dffq_1
X_2818_ _3542_/A3 _2818_/A2 _2833_/S VDD VDD VSS VSS gf180mcu_fd_sc_mcu7t5v0__nand2_2
XFILLER_105_414 VDD VDD VSS VSS gf180mcu_fd_sc_mcu7t5v0__fillcap_4
XFILLER_101_620 VDD VDD VSS VSS gf180mcu_fd_sc_mcu7t5v0__fillcap_8
XFILLER_87_854 VDD VDD VSS VSS gf180mcu_fd_sc_mcu7t5v0__fill_2
XTAP_TAPCELL_ROW_6_368 VDD VSS gf180mcu_fd_sc_mcu7t5v0__filltie
XFILLER_47_718 VDD VDD VSS VSS gf180mcu_fd_sc_mcu7t5v0__fillcap_8
XTAP_TAPCELL_ROW_70_1199 VDD VSS gf180mcu_fd_sc_mcu7t5v0__filltie
XTAP_TAPCELL_ROW_126_1922 VDD VSS gf180mcu_fd_sc_mcu7t5v0__filltie
XFILLER_100_185 VDD VDD VSS VSS gf180mcu_fd_sc_mcu7t5v0__fillcap_32
XFILLER_74_559 VDD VDD VSS VSS gf180mcu_fd_sc_mcu7t5v0__fillcap_8
XFILLER_15_626 VDD VDD VSS VSS gf180mcu_fd_sc_mcu7t5v0__fillcap_4
XFILLER_36_77 VDD VDD VSS VSS gf180mcu_fd_sc_mcu7t5v0__fillcap_16
XTAP_TAPCELL_ROW_25_610 VDD VSS gf180mcu_fd_sc_mcu7t5v0__filltie
XTAP_TAPCELL_ROW_53_974 VDD VSS gf180mcu_fd_sc_mcu7t5v0__filltie
XFILLER_7_836 VDD VDD VSS VSS gf180mcu_fd_sc_mcu7t5v0__fillcap_4
XFILLER_123_277 VDD VDD VSS VSS gf180mcu_fd_sc_mcu7t5v0__fill_2
XFILLER_97_629 VDD VDD VSS VSS gf180mcu_fd_sc_mcu7t5v0__fill_1
XFILLER_2_563 VDD VDD VSS VSS gf180mcu_fd_sc_mcu7t5v0__fillcap_32
XFILLER_38_707 VDD VDD VSS VSS gf180mcu_fd_sc_mcu7t5v0__fillcap_16
XFILLER_93_846 VDD VDD VSS VSS gf180mcu_fd_sc_mcu7t5v0__fill_1
XTAP_TAPCELL_ROW_88_1427 VDD VSS gf180mcu_fd_sc_mcu7t5v0__filltie
XFILLER_19_932 VDD VDD VSS VSS gf180mcu_fd_sc_mcu7t5v0__fill_2
XFILLER_65_548 VDD VDD VSS VSS gf180mcu_fd_sc_mcu7t5v0__fillcap_4
XFILLER_80_507 VDD VDD VSS VSS gf180mcu_fd_sc_mcu7t5v0__fillcap_16
XFILLER_65_559 VDD VDD VSS VSS gf180mcu_fd_sc_mcu7t5v0__fill_1
XFILLER_93_72 VDD VDD VSS VSS gf180mcu_fd_sc_mcu7t5v0__fillcap_64
X_1982_ _3967_/Q _1987_/A2 VDD VDD VSS VSS gf180mcu_fd_sc_mcu7t5v0__clkinv_1
X_3721_ _3721_/D _3740_/CLK _3721_/Q VDD VDD VSS VSS gf180mcu_fd_sc_mcu7t5v0__dffq_1
XTAP_TAPCELL_ROW_99_1578 VDD VSS gf180mcu_fd_sc_mcu7t5v0__filltie
XTAP_TAPCELL_ROW_99_1567 VDD VSS gf180mcu_fd_sc_mcu7t5v0__filltie
XFILLER_9_184 VDD VDD VSS VSS gf180mcu_fd_sc_mcu7t5v0__fillcap_16
X_3652_ _3652_/D _4157_/CLK _3652_/Q VDD VDD VSS VSS gf180mcu_fd_sc_mcu7t5v0__dffq_1
X_2603_ _4120_/Q _3537_/A1 _2801_/A1 VDD VDD VSS VSS gf180mcu_fd_sc_mcu7t5v0__nor2_1
XFILLER_61_2 VDD VDD VSS VSS gf180mcu_fd_sc_mcu7t5v0__fillcap_8
X_3583_ _3874_/Q _3882_/Q _3770_/Q _3778_/Q place76/Z place75/Z _3583_/Z VDD VDD VSS
+ VSS gf180mcu_fd_sc_mcu7t5v0__mux4_1
X_2534_ place80/Z _3738_/Q _2538_/S _3738_/D VDD VDD VSS VSS gf180mcu_fd_sc_mcu7t5v0__mux2_2
XFILLER_130_737 VDD VDD VSS VSS gf180mcu_fd_sc_mcu7t5v0__fillcap_16
XTAP_TAPCELL_ROW_110_1712 VDD VSS gf180mcu_fd_sc_mcu7t5v0__filltie
XFILLER_102_417 VDD VDD VSS VSS gf180mcu_fd_sc_mcu7t5v0__fill_2
X_4135_ _4135_/D _4148_/RN _4138_/CLK _4135_/Q VDD VDD VSS VSS gf180mcu_fd_sc_mcu7t5v0__dffrnq_1
XTAP_TAPCELL_ROW_3_327 VDD VSS gf180mcu_fd_sc_mcu7t5v0__filltie
XFILLER_28_217 VDD VDD VSS VSS gf180mcu_fd_sc_mcu7t5v0__fillcap_4
XFILLER_28_239 VDD VDD VSS VSS gf180mcu_fd_sc_mcu7t5v0__fillcap_4
XFILLER_83_356 VDD VDD VSS VSS gf180mcu_fd_sc_mcu7t5v0__fill_2
X_4066_ _4066_/D _4157_/RN _4076_/CLK _4066_/Q VDD VDD VSS VSS gf180mcu_fd_sc_mcu7t5v0__dffrnq_1
XTAP_TAPCELL_ROW_108_1696 VDD VSS gf180mcu_fd_sc_mcu7t5v0__filltie
XTAP_TAPCELL_ROW_108_1685 VDD VSS gf180mcu_fd_sc_mcu7t5v0__filltie
XFILLER_52_732 VDD VDD VSS VSS gf180mcu_fd_sc_mcu7t5v0__fill_2
XTAP_TAPCELL_ROW_121_1863 VDD VSS gf180mcu_fd_sc_mcu7t5v0__filltie
XTAP_TAPCELL_ROW_50_933 VDD VSS gf180mcu_fd_sc_mcu7t5v0__filltie
X_3919_ _3919_/D _4157_/RN _3976_/CLK _3919_/Q VDD VDD VSS VSS gf180mcu_fd_sc_mcu7t5v0__dffrnq_1
XFILLER_118_583 VDD VDD VSS VSS gf180mcu_fd_sc_mcu7t5v0__fillcap_8
XFILLER_106_734 VDD VDD VSS VSS gf180mcu_fd_sc_mcu7t5v0__fill_1
XFILLER_105_244 VDD VDD VSS VSS gf180mcu_fd_sc_mcu7t5v0__fillcap_16
XFILLER_0_6 VDD VDD VSS VSS gf180mcu_fd_sc_mcu7t5v0__fill_2
XFILLER_3_349 VDD VDD VSS VSS gf180mcu_fd_sc_mcu7t5v0__fill_1
XTAP_TAPCELL_ROW_72_1217 VDD VSS gf180mcu_fd_sc_mcu7t5v0__filltie
XTAP_TAPCELL_ROW_72_1228 VDD VSS gf180mcu_fd_sc_mcu7t5v0__filltie
XFILLER_120_225 VDD VDD VSS VSS gf180mcu_fd_sc_mcu7t5v0__fill_2
XFILLER_120_247 VDD VDD VSS VSS gf180mcu_fd_sc_mcu7t5v0__fillcap_16
XFILLER_87_695 VDD VDD VSS VSS gf180mcu_fd_sc_mcu7t5v0__fillcap_4
XFILLER_86_183 VDD VDD VSS VSS gf180mcu_fd_sc_mcu7t5v0__fill_1
XFILLER_19_206 VDD VDD VSS VSS gf180mcu_fd_sc_mcu7t5v0__fillcap_4
XFILLER_47_76 VDD VDD VSS VSS gf180mcu_fd_sc_mcu7t5v0__fill_2
XFILLER_47_559 VDD VDD VSS VSS gf180mcu_fd_sc_mcu7t5v0__fill_1
XFILLER_83_890 VDD VDD VSS VSS gf180mcu_fd_sc_mcu7t5v0__fillcap_4
XFILLER_63_42 VDD VDD VSS VSS gf180mcu_fd_sc_mcu7t5v0__fillcap_16
XTAP_TAPCELL_ROW_83_1368 VDD VSS gf180mcu_fd_sc_mcu7t5v0__filltie
XFILLER_42_231 VDD VDD VSS VSS gf180mcu_fd_sc_mcu7t5v0__fillcap_8
XPHY_EDGE_ROW_69_Right_69 VDD VSS gf180mcu_fd_sc_mcu7t5v0__endcap
XFILLER_15_489 VDD VDD VSS VSS gf180mcu_fd_sc_mcu7t5v0__fill_1
XFILLER_30_437 VDD VDD VSS VSS gf180mcu_fd_sc_mcu7t5v0__fill_1
XFILLER_128_303 VDD VDD VSS VSS gf180mcu_fd_sc_mcu7t5v0__fill_2
XFILLER_11_640 VDD VDD VSS VSS gf180mcu_fd_sc_mcu7t5v0__fill_1
XFILLER_8_37 VDD VDD VSS VSS gf180mcu_fd_sc_mcu7t5v0__fill_2
XFILLER_129_859 VDD VDD VSS VSS gf180mcu_fd_sc_mcu7t5v0__fill_2
XFILLER_10_172 VDD VDD VSS VSS gf180mcu_fd_sc_mcu7t5v0__fill_2
XPHY_EDGE_ROW_78_Right_78 VDD VSS gf180mcu_fd_sc_mcu7t5v0__endcap
XFILLER_112_715 VDD VDD VSS VSS gf180mcu_fd_sc_mcu7t5v0__fillcap_4
XFILLER_124_597 VDD VDD VSS VSS gf180mcu_fd_sc_mcu7t5v0__fillcap_64
X_2250_ _3952_/Q place63/Z place67/Z _3977_/Q _3920_/Q place72/Z _2251_/I VDD VDD
+ VSS VSS gf180mcu_fd_sc_mcu7t5v0__aoi222_1
XFILLER_97_459 VDD VDD VSS VSS gf180mcu_fd_sc_mcu7t5v0__fillcap_16
XFILLER_93_632 VDD VDD VSS VSS gf180mcu_fd_sc_mcu7t5v0__fillcap_64
X_2181_ _2112_/I _2152_/S _2181_/A3 place67/I VDD VDD VSS VSS gf180mcu_fd_sc_mcu7t5v0__nor3_1
XFILLER_77_194 VDD VDD VSS VSS gf180mcu_fd_sc_mcu7t5v0__fillcap_16
XFILLER_38_559 VDD VDD VSS VSS gf180mcu_fd_sc_mcu7t5v0__fill_2
XPHY_EDGE_ROW_87_Right_87 VDD VSS gf180mcu_fd_sc_mcu7t5v0__endcap
XTAP_TAPCELL_ROW_36_749 VDD VSS gf180mcu_fd_sc_mcu7t5v0__filltie
XFILLER_61_562 VDD VDD VSS VSS gf180mcu_fd_sc_mcu7t5v0__fillcap_32
XTAP_TAPCELL_ROW_16_495 VDD VSS gf180mcu_fd_sc_mcu7t5v0__filltie
X_1965_ _1965_/A1 _1965_/A2 _3083_/A2 VDD VDD VSS VSS gf180mcu_fd_sc_mcu7t5v0__nand2_1
X_3704_ _3704_/D _3738_/CLK _3704_/Q VDD VDD VSS VSS gf180mcu_fd_sc_mcu7t5v0__dffq_1
XFILLER_119_369 VDD VDD VSS VSS gf180mcu_fd_sc_mcu7t5v0__fillcap_16
XFILLER_119_347 VDD VDD VSS VSS gf180mcu_fd_sc_mcu7t5v0__fill_2
X_1896_ _3891_/Q _4138_/Q _4136_/Q _1897_/A3 VDD VDD VSS VSS gf180mcu_fd_sc_mcu7t5v0__oai21_1
XFILLER_128_870 VDD VDD VSS VSS gf180mcu_fd_sc_mcu7t5v0__fillcap_4
XPHY_EDGE_ROW_96_Right_96 VDD VSS gf180mcu_fd_sc_mcu7t5v0__endcap
X_3635_ _3635_/D _3732_/CLK _3635_/Q VDD VDD VSS VSS gf180mcu_fd_sc_mcu7t5v0__dffq_1
XFILLER_108_27 VDD VDD VSS VSS gf180mcu_fd_sc_mcu7t5v0__fillcap_8
XFILLER_115_586 VDD VDD VSS VSS gf180mcu_fd_sc_mcu7t5v0__fill_2
X_2517_ _3730_/Q place80/Z _2521_/S _3730_/D VDD VDD VSS VSS gf180mcu_fd_sc_mcu7t5v0__mux2_2
XFILLER_0_308 VDD VDD VSS VSS gf180mcu_fd_sc_mcu7t5v0__fillcap_32
X_3497_ _4124_/D _2182_/Z _3520_/A2 _3500_/I VDD VDD VSS VSS gf180mcu_fd_sc_mcu7t5v0__nor3_4
XFILLER_130_523 VDD VDD VSS VSS gf180mcu_fd_sc_mcu7t5v0__fill_2
XFILLER_102_225 VDD VDD VSS VSS gf180mcu_fd_sc_mcu7t5v0__fill_1
X_2448_ _3700_/Q _4074_/Q _2448_/S _3700_/D VDD VDD VSS VSS gf180mcu_fd_sc_mcu7t5v0__mux2_2
XFILLER_124_37 VDD VDD VSS VSS gf180mcu_fd_sc_mcu7t5v0__fillcap_32
XFILLER_102_247 VDD VDD VSS VSS gf180mcu_fd_sc_mcu7t5v0__fillcap_64
X_2379_ _2505_/A1 _2379_/A2 place59/I VDD VDD VSS VSS gf180mcu_fd_sc_mcu7t5v0__nor2_1
XFILLER_69_695 VDD VDD VSS VSS gf180mcu_fd_sc_mcu7t5v0__fillcap_4
XFILLER_83_142 VDD VDD VSS VSS gf180mcu_fd_sc_mcu7t5v0__fillcap_8
X_4118_ _4118_/D _4157_/RN _4148_/CLK _4118_/Q VDD VDD VSS VSS gf180mcu_fd_sc_mcu7t5v0__dffrnq_1
X_4049_ _4049_/D input92/Z _4130_/CLK _4049_/Q VDD VDD VSS VSS gf180mcu_fd_sc_mcu7t5v0__dffrnq_1
XFILLER_83_186 VDD VDD VSS VSS gf180mcu_fd_sc_mcu7t5v0__fillcap_16
XFILLER_37_592 VDD VDD VSS VSS gf180mcu_fd_sc_mcu7t5v0__fill_2
XFILLER_13_927 VDD VDD VSS VSS gf180mcu_fd_sc_mcu7t5v0__fillcap_4
XFILLER_80_893 VDD VDD VSS VSS gf180mcu_fd_sc_mcu7t5v0__fillcap_4
XFILLER_52_573 VDD VDD VSS VSS gf180mcu_fd_sc_mcu7t5v0__fillcap_4
XFILLER_126_807 VDD VDD VSS VSS gf180mcu_fd_sc_mcu7t5v0__fillcap_32
XFILLER_109_2 VDD VDD VSS VSS gf180mcu_fd_sc_mcu7t5v0__fillcap_4
XFILLER_106_597 VDD VDD VSS VSS gf180mcu_fd_sc_mcu7t5v0__fill_2
XFILLER_0_886 VDD VDD VSS VSS gf180mcu_fd_sc_mcu7t5v0__fillcap_32
XFILLER_75_632 VDD VDD VSS VSS gf180mcu_fd_sc_mcu7t5v0__fill_2
XFILLER_47_334 VDD VDD VSS VSS gf180mcu_fd_sc_mcu7t5v0__fillcap_16
XFILLER_75_698 VDD VDD VSS VSS gf180mcu_fd_sc_mcu7t5v0__fill_2
XFILLER_35_507 VDD VDD VSS VSS gf180mcu_fd_sc_mcu7t5v0__fillcap_8
XFILLER_28_592 VDD VDD VSS VSS gf180mcu_fd_sc_mcu7t5v0__fill_2
XFILLER_71_871 VDD VDD VSS VSS gf180mcu_fd_sc_mcu7t5v0__fillcap_4
XFILLER_31_702 VDD VDD VSS VSS gf180mcu_fd_sc_mcu7t5v0__fillcap_32
XTAP_TAPCELL_ROW_33_719 VDD VSS gf180mcu_fd_sc_mcu7t5v0__filltie
XFILLER_95_8 VDD VDD VSS VSS gf180mcu_fd_sc_mcu7t5v0__fill_1
XFILLER_15_275 VDD VDD VSS VSS gf180mcu_fd_sc_mcu7t5v0__fillcap_4
XFILLER_128_111 VDD VDD VSS VSS gf180mcu_fd_sc_mcu7t5v0__fill_1
XTAP_TAPCELL_ROW_13_454 VDD VSS gf180mcu_fd_sc_mcu7t5v0__filltie
XFILLER_30_289 VDD VDD VSS VSS gf180mcu_fd_sc_mcu7t5v0__fillcap_16
XFILLER_11_492 VDD VDD VSS VSS gf180mcu_fd_sc_mcu7t5v0__fillcap_64
XFILLER_11_481 VDD VDD VSS VSS gf180mcu_fd_sc_mcu7t5v0__fillcap_8
XFILLER_129_689 VDD VDD VSS VSS gf180mcu_fd_sc_mcu7t5v0__fillcap_4
XFILLER_128_177 VDD VDD VSS VSS gf180mcu_fd_sc_mcu7t5v0__fillcap_16
XFILLER_116_317 VDD VDD VSS VSS gf180mcu_fd_sc_mcu7t5v0__fillcap_64
XTAP_TAPCELL_ROW_96_1537 VDD VSS gf180mcu_fd_sc_mcu7t5v0__filltie
XFILLER_7_474 VDD VDD VSS VSS gf180mcu_fd_sc_mcu7t5v0__fill_1
XFILLER_109_380 VDD VDD VSS VSS gf180mcu_fd_sc_mcu7t5v0__fill_2
X_3420_ _3418_/Z _3419_/Z _3420_/Z VDD VDD VSS VSS gf180mcu_fd_sc_mcu7t5v0__and2_1
XFILLER_125_895 VDD VDD VSS VSS gf180mcu_fd_sc_mcu7t5v0__fillcap_8
XFILLER_98_757 VDD VDD VSS VSS gf180mcu_fd_sc_mcu7t5v0__fillcap_4
XFILLER_97_212 VDD VDD VSS VSS gf180mcu_fd_sc_mcu7t5v0__fillcap_32
X_2302_ _3413_/A1 _4098_/Q _2558_/A1 VDD VDD VSS VSS gf180mcu_fd_sc_mcu7t5v0__nand2_1
XFILLER_112_578 VDD VDD VSS VSS gf180mcu_fd_sc_mcu7t5v0__fill_2
XFILLER_98_768 VDD VDD VSS VSS gf180mcu_fd_sc_mcu7t5v0__fill_1
X_2233_ _2233_/A1 _2233_/A2 _2233_/ZN VDD VDD VSS VSS gf180mcu_fd_sc_mcu7t5v0__nand2_1
XFILLER_94_930 VDD VDD VSS VSS gf180mcu_fd_sc_mcu7t5v0__fillcap_4
XFILLER_85_418 VDD VDD VSS VSS gf180mcu_fd_sc_mcu7t5v0__fill_2
XFILLER_24_2 VDD VDD VSS VSS gf180mcu_fd_sc_mcu7t5v0__fillcap_32
XFILLER_39_824 VDD VDD VSS VSS gf180mcu_fd_sc_mcu7t5v0__fillcap_16
X_2164_ _4113_/Q _3516_/A1 VDD VDD VSS VSS gf180mcu_fd_sc_mcu7t5v0__clkinv_1
XFILLER_65_142 VDD VDD VSS VSS gf180mcu_fd_sc_mcu7t5v0__fillcap_16
X_2095_ _4146_/Q _2095_/A2 _2096_/A2 VDD VDD VSS VSS gf180mcu_fd_sc_mcu7t5v0__nand2_1
XTAP_TAPCELL_ROW_105_1655 VDD VSS gf180mcu_fd_sc_mcu7t5v0__filltie
XFILLER_21_212 VDD VDD VSS VSS gf180mcu_fd_sc_mcu7t5v0__fill_2
XFILLER_22_779 VDD VDD VSS VSS gf180mcu_fd_sc_mcu7t5v0__fillcap_16
X_1948_ _2079_/A1 _1948_/A2 _1948_/B1 _3896_/Q _1948_/C _1949_/B VDD VDD VSS VSS gf180mcu_fd_sc_mcu7t5v0__aoi221_2
XFILLER_108_807 VDD VDD VSS VSS gf180mcu_fd_sc_mcu7t5v0__fillcap_16
XFILLER_119_188 VDD VDD VSS VSS gf180mcu_fd_sc_mcu7t5v0__fillcap_16
XFILLER_119_166 VDD VDD VSS VSS gf180mcu_fd_sc_mcu7t5v0__fillcap_4
X_1879_ _3890_/Q _1892_/C VDD VDD VSS VSS gf180mcu_fd_sc_mcu7t5v0__clkinv_1
X_3618_ _3627_/I1 _4164_/Q _3618_/S _4164_/D VDD VDD VSS VSS gf180mcu_fd_sc_mcu7t5v0__mux2_2
XTAP_TAPCELL_ROW_56_1009 VDD VSS gf180mcu_fd_sc_mcu7t5v0__filltie
XFILLER_122_309 VDD VDD VSS VSS gf180mcu_fd_sc_mcu7t5v0__fillcap_4
XTAP_TAPCELL_ROW_116_1795 VDD VSS gf180mcu_fd_sc_mcu7t5v0__filltie
XFILLER_89_702 VDD VDD VSS VSS gf180mcu_fd_sc_mcu7t5v0__fillcap_16
X_3549_ _3545_/Z _3546_/Z _3547_/Z _3548_/Z place74/Z _4119_/Q _3549_/Z VDD VDD VSS
+ VSS gf180mcu_fd_sc_mcu7t5v0__mux4_1
XFILLER_103_556 VDD VDD VSS VSS gf180mcu_fd_sc_mcu7t5v0__fillcap_4
XFILLER_0_138 VDD VDD VSS VSS gf180mcu_fd_sc_mcu7t5v0__fillcap_32
XFILLER_103_578 VDD VDD VSS VSS gf180mcu_fd_sc_mcu7t5v0__fillcap_4
XFILLER_57_632 VDD VDD VSS VSS gf180mcu_fd_sc_mcu7t5v0__fillcap_64
XFILLER_69_492 VDD VDD VSS VSS gf180mcu_fd_sc_mcu7t5v0__fillcap_16
XFILLER_84_451 VDD VDD VSS VSS gf180mcu_fd_sc_mcu7t5v0__fillcap_4
XFILLER_29_367 VDD VDD VSS VSS gf180mcu_fd_sc_mcu7t5v0__fillcap_16
XFILLER_13_702 VDD VDD VSS VSS gf180mcu_fd_sc_mcu7t5v0__fillcap_16
XFILLER_71_156 VDD VDD VSS VSS gf180mcu_fd_sc_mcu7t5v0__fill_1
XTAP_TAPCELL_ROW_80_1327 VDD VSS gf180mcu_fd_sc_mcu7t5v0__filltie
XFILLER_25_562 VDD VDD VSS VSS gf180mcu_fd_sc_mcu7t5v0__fill_2
XFILLER_40_521 VDD VDD VSS VSS gf180mcu_fd_sc_mcu7t5v0__fillcap_4
XFILLER_9_717 VDD VDD VSS VSS gf180mcu_fd_sc_mcu7t5v0__fillcap_8
XFILLER_100_61 VDD VDD VSS VSS gf180mcu_fd_sc_mcu7t5v0__fillcap_4
XTAP_TAPCELL_ROW_10_413 VDD VSS gf180mcu_fd_sc_mcu7t5v0__filltie
XFILLER_126_615 VDD VDD VSS VSS gf180mcu_fd_sc_mcu7t5v0__fillcap_32
XFILLER_5_912 VDD VDD VSS VSS gf180mcu_fd_sc_mcu7t5v0__fillcap_16
XFILLER_5_27 VDD VDD VSS VSS gf180mcu_fd_sc_mcu7t5v0__fillcap_8
XFILLER_122_843 VDD VDD VSS VSS gf180mcu_fd_sc_mcu7t5v0__fill_2
XFILLER_79_212 VDD VDD VSS VSS gf180mcu_fd_sc_mcu7t5v0__fillcap_4
XFILLER_121_342 VDD VDD VSS VSS gf180mcu_fd_sc_mcu7t5v0__fill_2
XTAP_TAPCELL_ROW_91_1467 VDD VSS gf180mcu_fd_sc_mcu7t5v0__filltie
XFILLER_79_234 VDD VDD VSS VSS gf180mcu_fd_sc_mcu7t5v0__fillcap_8
XFILLER_36_827 VDD VDD VSS VSS gf180mcu_fd_sc_mcu7t5v0__fill_1
XFILLER_47_142 VDD VDD VSS VSS gf180mcu_fd_sc_mcu7t5v0__fillcap_4
XFILLER_91_933 VDD VDD VSS VSS gf180mcu_fd_sc_mcu7t5v0__fill_1
XFILLER_75_484 VDD VDD VSS VSS gf180mcu_fd_sc_mcu7t5v0__fillcap_4
XTAP_TAPCELL_ROW_18_524 VDD VSS gf180mcu_fd_sc_mcu7t5v0__filltie
XFILLER_90_465 VDD VDD VSS VSS gf180mcu_fd_sc_mcu7t5v0__fill_2
XFILLER_90_454 VDD VDD VSS VSS gf180mcu_fd_sc_mcu7t5v0__fill_1
XFILLER_44_893 VDD VDD VSS VSS gf180mcu_fd_sc_mcu7t5v0__fill_2
XTAP_TAPCELL_ROW_46_888 VDD VSS gf180mcu_fd_sc_mcu7t5v0__filltie
X_2920_ place84/Z _3907_/Q _2972_/S _3907_/D VDD VDD VSS VSS gf180mcu_fd_sc_mcu7t5v0__mux2_2
X_1802_ _3897_/Q _3898_/Q _1935_/A2 VDD VDD VSS VSS gf180mcu_fd_sc_mcu7t5v0__nor2_1
XTAP_TAPCELL_ROW_100_1585 VDD VSS gf180mcu_fd_sc_mcu7t5v0__filltie
X_2782_ place83/Z _3844_/Q _2782_/S _3844_/D VDD VDD VSS VSS gf180mcu_fd_sc_mcu7t5v0__mux2_2
XFILLER_117_626 VDD VDD VSS VSS gf180mcu_fd_sc_mcu7t5v0__fillcap_4
Xhold205 s_axi_wdata[15] hold205/Z VDD VDD VSS VSS gf180mcu_fd_sc_mcu7t5v0__dlyc_1
XFILLER_7_282 VDD VDD VSS VSS gf180mcu_fd_sc_mcu7t5v0__fillcap_4
Xhold216 s_axi_awaddr[2] hold216/Z VDD VDD VSS VSS gf180mcu_fd_sc_mcu7t5v0__dlyc_1
Xhold227 s_axi_wdata[21] hold227/Z VDD VDD VSS VSS gf180mcu_fd_sc_mcu7t5v0__dlyc_1
XFILLER_131_139 VDD VDD VSS VSS gf180mcu_fd_sc_mcu7t5v0__fill_1
XFILLER_98_510 VDD VDD VSS VSS gf180mcu_fd_sc_mcu7t5v0__fillcap_8
XFILLER_124_191 VDD VDD VSS VSS gf180mcu_fd_sc_mcu7t5v0__fillcap_8
X_3334_ _4082_/Q _3362_/A2 _3334_/A3 _4083_/Q _3337_/A2 VDD VDD VSS VSS gf180mcu_fd_sc_mcu7t5v0__nor4_1
XFILLER_112_375 VDD VDD VSS VSS gf180mcu_fd_sc_mcu7t5v0__fill_2
XFILLER_85_226 VDD VDD VSS VSS gf180mcu_fd_sc_mcu7t5v0__fill_1
X_3265_ _4062_/Q _3256_/Z _3265_/B _3266_/I VDD VDD VSS VSS gf180mcu_fd_sc_mcu7t5v0__aoi21_1
XFILLER_58_429 VDD VDD VSS VSS gf180mcu_fd_sc_mcu7t5v0__fill_1
XFILLER_112_397 VDD VDD VSS VSS gf180mcu_fd_sc_mcu7t5v0__fillcap_32
X_2216_ _3892_/Q place68/Z _2216_/B1 _4066_/Q place63/Z _3940_/Q _2217_/A3 VDD VDD
+ VSS VSS gf180mcu_fd_sc_mcu7t5v0__aoi222_1
XFILLER_39_632 VDD VDD VSS VSS gf180mcu_fd_sc_mcu7t5v0__fillcap_64
X_3196_ _4037_/Q _4005_/Q _4129_/D _4037_/D VDD VDD VSS VSS gf180mcu_fd_sc_mcu7t5v0__mux2_2
X_2147_ _2143_/Z _2144_/Z _2145_/Z _2146_/Z place77/Z _4094_/Q _2147_/Z VDD VDD VSS
+ VSS gf180mcu_fd_sc_mcu7t5v0__mux4_1
X_2078_ _4142_/Q _4141_/Q _4140_/Q _2079_/A4 VDD VDD VSS VSS gf180mcu_fd_sc_mcu7t5v0__nand3_1
XFILLER_53_134 VDD VDD VSS VSS gf180mcu_fd_sc_mcu7t5v0__fillcap_4
XFILLER_53_189 VDD VDD VSS VSS gf180mcu_fd_sc_mcu7t5v0__fillcap_16
XFILLER_50_874 VDD VDD VSS VSS gf180mcu_fd_sc_mcu7t5v0__fill_1
XTAP_TAPCELL_ROW_118_1824 VDD VSS gf180mcu_fd_sc_mcu7t5v0__filltie
XFILLER_5_208 VDD VDD VSS VSS gf180mcu_fd_sc_mcu7t5v0__fill_2
XFILLER_108_659 VDD VDD VSS VSS gf180mcu_fd_sc_mcu7t5v0__fillcap_4
XFILLER_131_651 VDD VDD VSS VSS gf180mcu_fd_sc_mcu7t5v0__fillcap_16
XFILLER_131_695 VDD VDD VSS VSS gf180mcu_fd_sc_mcu7t5v0__fillcap_4
XFILLER_39_44 VDD VDD VSS VSS gf180mcu_fd_sc_mcu7t5v0__fillcap_4
XTAP_TAPCELL_ROW_129_1964 VDD VSS gf180mcu_fd_sc_mcu7t5v0__filltie
XFILLER_29_142 VDD VDD VSS VSS gf180mcu_fd_sc_mcu7t5v0__fillcap_8
XFILLER_55_10 VDD VDD VSS VSS gf180mcu_fd_sc_mcu7t5v0__fill_1
XPHY_EDGE_ROW_105_Right_105 VDD VSS gf180mcu_fd_sc_mcu7t5v0__endcap
XFILLER_26_893 VDD VDD VSS VSS gf180mcu_fd_sc_mcu7t5v0__fillcap_8
XTAP_TAPCELL_ROW_43_847 VDD VSS gf180mcu_fd_sc_mcu7t5v0__filltie
XFILLER_71_42 VDD VDD VSS VSS gf180mcu_fd_sc_mcu7t5v0__fillcap_4
XTAP_TAPCELL_ROW_23_582 VDD VSS gf180mcu_fd_sc_mcu7t5v0__filltie
XFILLER_4_263 VDD VDD VSS VSS gf180mcu_fd_sc_mcu7t5v0__fill_2
XFILLER_122_651 VDD VDD VSS VSS gf180mcu_fd_sc_mcu7t5v0__fill_1
XFILLER_4_296 VDD VDD VSS VSS gf180mcu_fd_sc_mcu7t5v0__fillcap_4
XFILLER_20_90 VDD VDD VSS VSS gf180mcu_fd_sc_mcu7t5v0__fillcap_8
XFILLER_110_868 VDD VDD VSS VSS gf180mcu_fd_sc_mcu7t5v0__fillcap_4
X_3050_ _4047_/Q _3967_/Q _3081_/S _3967_/D VDD VDD VSS VSS gf180mcu_fd_sc_mcu7t5v0__mux2_2
X_2001_ _2001_/A1 _4054_/Q _4053_/Q _4058_/Q _3519_/A2 VDD VDD VSS VSS gf180mcu_fd_sc_mcu7t5v0__nor4_4
XFILLER_82_229 VDD VDD VSS VSS gf180mcu_fd_sc_mcu7t5v0__fill_2
XFILLER_64_933 VDD VDD VSS VSS gf180mcu_fd_sc_mcu7t5v0__fill_1
XFILLER_35_189 VDD VDD VSS VSS gf180mcu_fd_sc_mcu7t5v0__fill_1
XFILLER_51_627 VDD VDD VSS VSS gf180mcu_fd_sc_mcu7t5v0__fill_2
X_3952_ _3952_/D _2279_/I _3978_/CLK _3952_/Q VDD VDD VSS VSS gf180mcu_fd_sc_mcu7t5v0__dffrnq_1
XTAP_TAPCELL_ROW_102_1614 VDD VSS gf180mcu_fd_sc_mcu7t5v0__filltie
XFILLER_16_381 VDD VDD VSS VSS gf180mcu_fd_sc_mcu7t5v0__fillcap_4
X_2903_ _2903_/A1 _2900_/S _2903_/B _3899_/D VDD VDD VSS VSS gf180mcu_fd_sc_mcu7t5v0__oai21_1
XFILLER_32_874 VDD VDD VSS VSS gf180mcu_fd_sc_mcu7t5v0__fill_1
X_3883_ _3883_/D _4123_/CLK _3883_/Q VDD VDD VSS VSS gf180mcu_fd_sc_mcu7t5v0__dffq_1
XFILLER_31_384 VDD VDD VSS VSS gf180mcu_fd_sc_mcu7t5v0__fillcap_4
XFILLER_129_294 VDD VDD VSS VSS gf180mcu_fd_sc_mcu7t5v0__fillcap_8
XFILLER_117_434 VDD VDD VSS VSS gf180mcu_fd_sc_mcu7t5v0__fill_2
XFILLER_105_618 VDD VDD VSS VSS gf180mcu_fd_sc_mcu7t5v0__fillcap_4
X_2696_ place90/Z _3805_/Q _2710_/S _3805_/D VDD VDD VSS VSS gf180mcu_fd_sc_mcu7t5v0__mux2_2
XFILLER_116_27 VDD VDD VSS VSS gf180mcu_fd_sc_mcu7t5v0__fillcap_8
XTAP_TAPCELL_ROW_113_1754 VDD VSS gf180mcu_fd_sc_mcu7t5v0__filltie
XFILLER_98_384 VDD VDD VSS VSS gf180mcu_fd_sc_mcu7t5v0__fill_1
XFILLER_98_351 VDD VDD VSS VSS gf180mcu_fd_sc_mcu7t5v0__fill_1
X_3317_ _3353_/B _4148_/Q _3320_/A2 VDD VDD VSS VSS gf180mcu_fd_sc_mcu7t5v0__nand2_1
XFILLER_27_602 VDD VDD VSS VSS gf180mcu_fd_sc_mcu7t5v0__fillcap_8
X_3179_ _4029_/Q _3997_/Q _4129_/D _4029_/D VDD VDD VSS VSS gf180mcu_fd_sc_mcu7t5v0__mux2_2
XFILLER_26_101 VDD VDD VSS VSS gf180mcu_fd_sc_mcu7t5v0__fillcap_4
XTAP_TAPCELL_ROW_1_299 VDD VSS gf180mcu_fd_sc_mcu7t5v0__filltie
XFILLER_42_605 VDD VDD VSS VSS gf180mcu_fd_sc_mcu7t5v0__fill_1
XTAP_TAPCELL_ROW_64_1119 VDD VSS gf180mcu_fd_sc_mcu7t5v0__filltie
XTAP_TAPCELL_ROW_124_1894 VDD VSS gf180mcu_fd_sc_mcu7t5v0__filltie
XFILLER_25_57 VDD VDD VSS VSS gf180mcu_fd_sc_mcu7t5v0__fillcap_8
XTAP_TAPCELL_ROW_40_806 VDD VSS gf180mcu_fd_sc_mcu7t5v0__filltie
XTAP_TAPCELL_ROW_20_541 VDD VSS gf180mcu_fd_sc_mcu7t5v0__filltie
XTAP_TAPCELL_ROW_20_552 VDD VSS gf180mcu_fd_sc_mcu7t5v0__filltie
XTAP_TAPCELL_ROW_75_1259 VDD VSS gf180mcu_fd_sc_mcu7t5v0__filltie
XFILLER_2_734 VDD VDD VSS VSS gf180mcu_fd_sc_mcu7t5v0__fill_1
XFILLER_104_662 VDD VDD VSS VSS gf180mcu_fd_sc_mcu7t5v0__fill_2
XTAP_TAPCELL_ROW_9_399 VDD VSS gf180mcu_fd_sc_mcu7t5v0__filltie
XFILLER_1_244 VDD VDD VSS VSS gf180mcu_fd_sc_mcu7t5v0__fillcap_16
XFILLER_103_194 VDD VDD VSS VSS gf180mcu_fd_sc_mcu7t5v0__fill_1
XTAP_TAPCELL_ROW_48_906 VDD VSS gf180mcu_fd_sc_mcu7t5v0__filltie
XFILLER_46_933 VDD VDD VSS VSS gf180mcu_fd_sc_mcu7t5v0__fill_1
XTAP_TAPCELL_ROW_28_652 VDD VSS gf180mcu_fd_sc_mcu7t5v0__filltie
XFILLER_60_402 VDD VDD VSS VSS gf180mcu_fd_sc_mcu7t5v0__fillcap_32
XFILLER_72_251 VDD VDD VSS VSS gf180mcu_fd_sc_mcu7t5v0__fill_1
XTAP_TAPCELL_ROW_86_1399 VDD VSS gf180mcu_fd_sc_mcu7t5v0__filltie
XFILLER_82_52 VDD VDD VSS VSS gf180mcu_fd_sc_mcu7t5v0__fillcap_4
XFILLER_14_885 VDD VDD VSS VSS gf180mcu_fd_sc_mcu7t5v0__fillcap_4
XFILLER_60_457 VDD VDD VSS VSS gf180mcu_fd_sc_mcu7t5v0__fillcap_8
XFILLER_13_373 VDD VDD VSS VSS gf180mcu_fd_sc_mcu7t5v0__fillcap_8
XFILLER_9_322 VDD VDD VSS VSS gf180mcu_fd_sc_mcu7t5v0__fillcap_16
XFILLER_127_776 VDD VDD VSS VSS gf180mcu_fd_sc_mcu7t5v0__fill_1
XFILLER_126_253 VDD VDD VSS VSS gf180mcu_fd_sc_mcu7t5v0__fill_1
X_2550_ _3745_/Q _4071_/Q _2556_/S _3745_/D VDD VDD VSS VSS gf180mcu_fd_sc_mcu7t5v0__mux2_2
X_2481_ _3714_/Q place80/Z _2485_/S _3714_/D VDD VDD VSS VSS gf180mcu_fd_sc_mcu7t5v0__mux2_2
X_4151_ _4151_/D _4157_/RN _4153_/CLK _4151_/Q VDD VDD VSS VSS gf180mcu_fd_sc_mcu7t5v0__dffrnq_1
XFILLER_68_524 VDD VDD VSS VSS gf180mcu_fd_sc_mcu7t5v0__fill_1
XFILLER_96_877 VDD VDD VSS VSS gf180mcu_fd_sc_mcu7t5v0__fillcap_32
X_4082_ _4082_/D input92/Z _4163_/CLK _4082_/Q VDD VDD VSS VSS gf180mcu_fd_sc_mcu7t5v0__dffrnq_1
X_3102_ _3992_/Q _3102_/I1 _3160_/S _3992_/D VDD VDD VSS VSS gf180mcu_fd_sc_mcu7t5v0__mux2_2
X_3033_ _3960_/Q _4048_/Q _3041_/S _3960_/D VDD VDD VSS VSS gf180mcu_fd_sc_mcu7t5v0__mux2_2
XFILLER_55_229 VDD VDD VSS VSS gf180mcu_fd_sc_mcu7t5v0__fill_1
XFILLER_64_785 VDD VDD VSS VSS gf180mcu_fd_sc_mcu7t5v0__fillcap_16
XFILLER_23_126 VDD VDD VSS VSS gf180mcu_fd_sc_mcu7t5v0__fillcap_8
X_3935_ _3935_/D _4157_/RN _4127_/CLK _3935_/Q VDD VDD VSS VSS gf180mcu_fd_sc_mcu7t5v0__dffrnq_1
XFILLER_51_468 VDD VDD VSS VSS gf180mcu_fd_sc_mcu7t5v0__fillcap_16
XFILLER_20_877 VDD VDD VSS VSS gf180mcu_fd_sc_mcu7t5v0__fillcap_32
X_3866_ _3866_/D _3866_/CLK _3866_/Q VDD VDD VSS VSS gf180mcu_fd_sc_mcu7t5v0__dffq_1
X_3797_ _3797_/D _3806_/CLK _3797_/Q VDD VDD VSS VSS gf180mcu_fd_sc_mcu7t5v0__dffq_1
X_2748_ _2748_/A1 _3537_/A1 _2581_/Z place44/I VDD VDD VSS VSS gf180mcu_fd_sc_mcu7t5v0__nor3_2
XFILLER_106_927 VDD VDD VSS VSS gf180mcu_fd_sc_mcu7t5v0__fillcap_4
X_2679_ place90/Z _3797_/Q _2693_/S _3797_/D VDD VDD VSS VSS gf180mcu_fd_sc_mcu7t5v0__mux2_2
XFILLER_113_492 VDD VDD VSS VSS gf180mcu_fd_sc_mcu7t5v0__fillcap_16
XFILLER_101_632 VDD VDD VSS VSS gf180mcu_fd_sc_mcu7t5v0__fillcap_64
XFILLER_101_610 VDD VDD VSS VSS gf180mcu_fd_sc_mcu7t5v0__fillcap_4
XTAP_TAPCELL_ROW_6_358 VDD VSS gf180mcu_fd_sc_mcu7t5v0__filltie
XTAP_TAPCELL_ROW_6_369 VDD VSS gf180mcu_fd_sc_mcu7t5v0__filltie
XTAP_TAPCELL_ROW_126_1923 VDD VSS gf180mcu_fd_sc_mcu7t5v0__filltie
XFILLER_74_527 VDD VDD VSS VSS gf180mcu_fd_sc_mcu7t5v0__fillcap_32
XFILLER_28_933 VDD VDD VSS VSS gf180mcu_fd_sc_mcu7t5v0__fill_1
XFILLER_39_270 VDD VDD VSS VSS gf180mcu_fd_sc_mcu7t5v0__fill_1
XFILLER_36_45 VDD VDD VSS VSS gf180mcu_fd_sc_mcu7t5v0__fill_2
XFILLER_82_593 VDD VDD VSS VSS gf180mcu_fd_sc_mcu7t5v0__fill_2
XTAP_TAPCELL_ROW_25_611 VDD VSS gf180mcu_fd_sc_mcu7t5v0__filltie
XFILLER_42_457 VDD VDD VSS VSS gf180mcu_fd_sc_mcu7t5v0__fillcap_64
XTAP_TAPCELL_ROW_53_975 VDD VSS gf180mcu_fd_sc_mcu7t5v0__filltie
XFILLER_10_343 VDD VDD VSS VSS gf180mcu_fd_sc_mcu7t5v0__fill_1
XFILLER_10_321 VDD VDD VSS VSS gf180mcu_fd_sc_mcu7t5v0__fill_1
XFILLER_52_88 VDD VDD VSS VSS gf180mcu_fd_sc_mcu7t5v0__fillcap_16
XFILLER_109_710 VDD VDD VSS VSS gf180mcu_fd_sc_mcu7t5v0__fill_2
XFILLER_109_754 VDD VDD VSS VSS gf180mcu_fd_sc_mcu7t5v0__fillcap_16
XFILLER_10_387 VDD VDD VSS VSS gf180mcu_fd_sc_mcu7t5v0__fillcap_8
XFILLER_123_212 VDD VDD VSS VSS gf180mcu_fd_sc_mcu7t5v0__fillcap_16
XFILLER_96_107 VDD VDD VSS VSS gf180mcu_fd_sc_mcu7t5v0__fill_2
XFILLER_2_597 VDD VDD VSS VSS gf180mcu_fd_sc_mcu7t5v0__fillcap_16
XFILLER_93_836 VDD VDD VSS VSS gf180mcu_fd_sc_mcu7t5v0__fillcap_4
XFILLER_92_313 VDD VDD VSS VSS gf180mcu_fd_sc_mcu7t5v0__fill_2
XTAP_TAPCELL_ROW_88_1428 VDD VSS gf180mcu_fd_sc_mcu7t5v0__filltie
XFILLER_93_51 VDD VDD VSS VSS gf180mcu_fd_sc_mcu7t5v0__fillcap_4
X_1981_ _4087_/Q _3389_/A1 VDD VDD VSS VSS gf180mcu_fd_sc_mcu7t5v0__clkinv_1
XFILLER_20_107 VDD VDD VSS VSS gf180mcu_fd_sc_mcu7t5v0__fillcap_8
XFILLER_60_298 VDD VDD VSS VSS gf180mcu_fd_sc_mcu7t5v0__fillcap_16
X_3720_ _3720_/D _3738_/CLK _3720_/Q VDD VDD VSS VSS gf180mcu_fd_sc_mcu7t5v0__dffq_1
Xclkbuf_leaf_40_clk clkload4/I _3750_/CLK VDD VDD VSS VSS gf180mcu_fd_sc_mcu7t5v0__clkbuf_8
XTAP_TAPCELL_ROW_99_1568 VDD VSS gf180mcu_fd_sc_mcu7t5v0__filltie
XFILLER_9_174 VDD VDD VSS VSS gf180mcu_fd_sc_mcu7t5v0__fill_2
X_3651_ _3651_/D _3755_/CLK _3651_/Q VDD VDD VSS VSS gf180mcu_fd_sc_mcu7t5v0__dffq_1
XTAP_TAPCELL_ROW_99_1579 VDD VSS gf180mcu_fd_sc_mcu7t5v0__filltie
X_3582_ _3842_/Q _3850_/Q _3858_/Q _3866_/Q place76/Z place75/Z _3582_/Z VDD VDD VSS
+ VSS gf180mcu_fd_sc_mcu7t5v0__mux4_1
X_2602_ _4121_/Q _3537_/A1 VDD VDD VSS VSS gf180mcu_fd_sc_mcu7t5v0__clkinv_1
XFILLER_127_562 VDD VDD VSS VSS gf180mcu_fd_sc_mcu7t5v0__fillcap_8
XFILLER_115_702 VDD VDD VSS VSS gf180mcu_fd_sc_mcu7t5v0__fillcap_64
XFILLER_54_2 VDD VDD VSS VSS gf180mcu_fd_sc_mcu7t5v0__fillcap_16
XFILLER_130_727 VDD VDD VSS VSS gf180mcu_fd_sc_mcu7t5v0__fill_2
XTAP_TAPCELL_ROW_110_1713 VDD VSS gf180mcu_fd_sc_mcu7t5v0__filltie
X_2464_ _4073_/Q _3707_/Q _2466_/S _3707_/D VDD VDD VSS VSS gf180mcu_fd_sc_mcu7t5v0__mux2_2
X_2395_ _3676_/Q _4074_/Q _2395_/S _3676_/D VDD VDD VSS VSS gf180mcu_fd_sc_mcu7t5v0__mux2_2
X_4134_ _4134_/D _4148_/RN _4138_/CLK _4134_/Q VDD VDD VSS VSS gf180mcu_fd_sc_mcu7t5v0__dffrnq_1
XFILLER_84_803 VDD VDD VSS VSS gf180mcu_fd_sc_mcu7t5v0__fill_2
XFILLER_96_685 VDD VDD VSS VSS gf180mcu_fd_sc_mcu7t5v0__fill_1
XFILLER_83_324 VDD VDD VSS VSS gf180mcu_fd_sc_mcu7t5v0__fillcap_16
XTAP_TAPCELL_ROW_3_328 VDD VSS gf180mcu_fd_sc_mcu7t5v0__filltie
XFILLER_56_527 VDD VDD VSS VSS gf180mcu_fd_sc_mcu7t5v0__fillcap_16
XFILLER_84_869 VDD VDD VSS VSS gf180mcu_fd_sc_mcu7t5v0__fillcap_4
X_4065_ _4065_/D input92/Z _4076_/CLK _4065_/Q VDD VDD VSS VSS gf180mcu_fd_sc_mcu7t5v0__dffrnq_1
X_3016_ _3952_/Q _4040_/Q _3041_/S _3952_/D VDD VDD VSS VSS gf180mcu_fd_sc_mcu7t5v0__mux2_2
XFILLER_71_508 VDD VDD VSS VSS gf180mcu_fd_sc_mcu7t5v0__fillcap_8
XTAP_TAPCELL_ROW_108_1686 VDD VSS gf180mcu_fd_sc_mcu7t5v0__filltie
XTAP_TAPCELL_ROW_121_1853 VDD VSS gf180mcu_fd_sc_mcu7t5v0__filltie
XFILLER_24_457 VDD VDD VSS VSS gf180mcu_fd_sc_mcu7t5v0__fillcap_64
XTAP_TAPCELL_ROW_121_1864 VDD VSS gf180mcu_fd_sc_mcu7t5v0__filltie
XTAP_TAPCELL_ROW_50_934 VDD VSS gf180mcu_fd_sc_mcu7t5v0__filltie
XFILLER_51_276 VDD VDD VSS VSS gf180mcu_fd_sc_mcu7t5v0__fillcap_4
X_3918_ _3918_/D _2279_/I _3975_/CLK _3918_/Q VDD VDD VSS VSS gf180mcu_fd_sc_mcu7t5v0__dffrnq_1
Xclkbuf_leaf_31_clk clkload6/I _3738_/CLK VDD VDD VSS VSS gf180mcu_fd_sc_mcu7t5v0__clkbuf_8
X_3849_ _3849_/D _3865_/CLK _3849_/Q VDD VDD VSS VSS gf180mcu_fd_sc_mcu7t5v0__dffq_1
XFILLER_20_663 VDD VDD VSS VSS gf180mcu_fd_sc_mcu7t5v0__fill_2
XFILLER_118_551 VDD VDD VSS VSS gf180mcu_fd_sc_mcu7t5v0__fillcap_32
XFILLER_4_807 VDD VDD VSS VSS gf180mcu_fd_sc_mcu7t5v0__fillcap_64
XTAP_TAPCELL_ROW_30_680 VDD VSS gf180mcu_fd_sc_mcu7t5v0__filltie
XFILLER_105_212 VDD VDD VSS VSS gf180mcu_fd_sc_mcu7t5v0__fillcap_32
XFILLER_3_339 VDD VDD VSS VSS gf180mcu_fd_sc_mcu7t5v0__fillcap_8
XTAP_TAPCELL_ROW_72_1218 VDD VSS gf180mcu_fd_sc_mcu7t5v0__filltie
XFILLER_121_749 VDD VDD VSS VSS gf180mcu_fd_sc_mcu7t5v0__fillcap_16
XFILLER_105_289 VDD VDD VSS VSS gf180mcu_fd_sc_mcu7t5v0__fillcap_32
XFILLER_86_173 VDD VDD VSS VSS gf180mcu_fd_sc_mcu7t5v0__fill_2
XFILLER_74_313 VDD VDD VSS VSS gf180mcu_fd_sc_mcu7t5v0__fill_2
XFILLER_47_44 VDD VDD VSS VSS gf180mcu_fd_sc_mcu7t5v0__fill_1
XFILLER_47_66 VDD VDD VSS VSS gf180mcu_fd_sc_mcu7t5v0__fillcap_4
XFILLER_16_925 VDD VDD VSS VSS gf180mcu_fd_sc_mcu7t5v0__fillcap_8
XFILLER_103_72 VDD VDD VSS VSS gf180mcu_fd_sc_mcu7t5v0__fillcap_16
XFILLER_27_273 VDD VDD VSS VSS gf180mcu_fd_sc_mcu7t5v0__fillcap_4
XTAP_TAPCELL_ROW_38_780 VDD VSS gf180mcu_fd_sc_mcu7t5v0__filltie
XTAP_TAPCELL_ROW_83_1369 VDD VSS gf180mcu_fd_sc_mcu7t5v0__filltie
XFILLER_31_906 VDD VDD VSS VSS gf180mcu_fd_sc_mcu7t5v0__fillcap_4
XFILLER_31_928 VDD VDD VSS VSS gf180mcu_fd_sc_mcu7t5v0__fillcap_4
XFILLER_42_243 VDD VDD VSS VSS gf180mcu_fd_sc_mcu7t5v0__fill_2
XFILLER_129_816 VDD VDD VSS VSS gf180mcu_fd_sc_mcu7t5v0__fillcap_16
Xclkbuf_leaf_22_clk clkload5/I _3976_/CLK VDD VDD VSS VSS gf180mcu_fd_sc_mcu7t5v0__clkbuf_8
XFILLER_8_27 VDD VDD VSS VSS gf180mcu_fd_sc_mcu7t5v0__fillcap_8
XFILLER_109_562 VDD VDD VSS VSS gf180mcu_fd_sc_mcu7t5v0__fillcap_64
XFILLER_124_521 VDD VDD VSS VSS gf180mcu_fd_sc_mcu7t5v0__fillcap_4
XFILLER_97_438 VDD VDD VSS VSS gf180mcu_fd_sc_mcu7t5v0__fillcap_8
X_2180_ _3937_/Q place63/Z _2187_/A2 VDD VDD VSS VSS gf180mcu_fd_sc_mcu7t5v0__nand2_1
XFILLER_38_527 VDD VDD VSS VSS gf180mcu_fd_sc_mcu7t5v0__fillcap_32
XPHY_EDGE_ROW_69_Left_202 VDD VSS gf180mcu_fd_sc_mcu7t5v0__endcap
XFILLER_65_346 VDD VDD VSS VSS gf180mcu_fd_sc_mcu7t5v0__fillcap_4
XFILLER_81_839 VDD VDD VSS VSS gf180mcu_fd_sc_mcu7t5v0__fill_1
XFILLER_33_276 VDD VDD VSS VSS gf180mcu_fd_sc_mcu7t5v0__fillcap_4
Xclkbuf_leaf_13_clk clkload1/I _4045_/CLK VDD VDD VSS VSS gf180mcu_fd_sc_mcu7t5v0__clkbuf_8
XPHY_EDGE_ROW_78_Left_211 VDD VSS gf180mcu_fd_sc_mcu7t5v0__endcap
XTAP_TAPCELL_ROW_16_496 VDD VSS gf180mcu_fd_sc_mcu7t5v0__filltie
X_1964_ _4131_/Q _1965_/A2 VDD VDD VSS VSS gf180mcu_fd_sc_mcu7t5v0__clkinv_1
X_3703_ _3703_/D _3729_/CLK _3703_/Q VDD VDD VSS VSS gf180mcu_fd_sc_mcu7t5v0__dffq_1
X_3634_ _3634_/D _3733_/CLK _3634_/Q VDD VDD VSS VSS gf180mcu_fd_sc_mcu7t5v0__dffq_1
X_1895_ _3889_/Q _2041_/A1 _1822_/Z _1898_/A2 VDD VDD VSS VSS gf180mcu_fd_sc_mcu7t5v0__nand3_1
XFILLER_128_893 VDD VDD VSS VSS gf180mcu_fd_sc_mcu7t5v0__fill_2
X_3565_ _3564_/Z _4151_/Q _3600_/S _4151_/D VDD VDD VSS VSS gf180mcu_fd_sc_mcu7t5v0__mux2_2
XTAP_TAPCELL_ROW_58_1040 VDD VSS gf180mcu_fd_sc_mcu7t5v0__filltie
XFILLER_89_928 VDD VDD VSS VSS gf180mcu_fd_sc_mcu7t5v0__fillcap_4
X_3496_ _4102_/Q _3496_/A2 _3496_/B _3496_/C _4109_/D VDD VDD VSS VSS gf180mcu_fd_sc_mcu7t5v0__oai211_2
XFILLER_130_513 VDD VDD VSS VSS gf180mcu_fd_sc_mcu7t5v0__fill_2
XPHY_EDGE_ROW_87_Left_220 VDD VSS gf180mcu_fd_sc_mcu7t5v0__endcap
XFILLER_130_546 VDD VDD VSS VSS gf180mcu_fd_sc_mcu7t5v0__fillcap_4
XFILLER_57_836 VDD VDD VSS VSS gf180mcu_fd_sc_mcu7t5v0__fillcap_4
XFILLER_68_173 VDD VDD VSS VSS gf180mcu_fd_sc_mcu7t5v0__fill_2
XFILLER_57_858 VDD VDD VSS VSS gf180mcu_fd_sc_mcu7t5v0__fillcap_4
X_4117_ _4117_/D _4148_/RN _4148_/CLK _4117_/Q VDD VDD VSS VSS gf180mcu_fd_sc_mcu7t5v0__dffrnq_1
X_4048_ _4048_/D _4148_/RN _4136_/CLK _4048_/Q VDD VDD VSS VSS gf180mcu_fd_sc_mcu7t5v0__dffrnq_1
XTAP_TAPCELL_ROW_69_1180 VDD VSS gf180mcu_fd_sc_mcu7t5v0__filltie
XFILLER_71_349 VDD VDD VSS VSS gf180mcu_fd_sc_mcu7t5v0__fill_1
XFILLER_25_766 VDD VDD VSS VSS gf180mcu_fd_sc_mcu7t5v0__fillcap_4
XFILLER_40_769 VDD VDD VSS VSS gf180mcu_fd_sc_mcu7t5v0__fillcap_4
XFILLER_118_381 VDD VDD VSS VSS gf180mcu_fd_sc_mcu7t5v0__fillcap_4
XFILLER_4_659 VDD VDD VSS VSS gf180mcu_fd_sc_mcu7t5v0__fillcap_4
XFILLER_106_576 VDD VDD VSS VSS gf180mcu_fd_sc_mcu7t5v0__fillcap_16
XFILLER_121_524 VDD VDD VSS VSS gf180mcu_fd_sc_mcu7t5v0__fill_2
XFILLER_79_438 VDD VDD VSS VSS gf180mcu_fd_sc_mcu7t5v0__fillcap_4
XFILLER_114_82 VDD VDD VSS VSS gf180mcu_fd_sc_mcu7t5v0__fillcap_8
XFILLER_75_666 VDD VDD VSS VSS gf180mcu_fd_sc_mcu7t5v0__fill_2
XFILLER_16_722 VDD VDD VSS VSS gf180mcu_fd_sc_mcu7t5v0__fillcap_8
XFILLER_71_850 VDD VDD VSS VSS gf180mcu_fd_sc_mcu7t5v0__fillcap_4
XTAP_TAPCELL_ROW_33_709 VDD VSS gf180mcu_fd_sc_mcu7t5v0__filltie
XFILLER_43_596 VDD VDD VSS VSS gf180mcu_fd_sc_mcu7t5v0__fillcap_32
XFILLER_70_360 VDD VDD VSS VSS gf180mcu_fd_sc_mcu7t5v0__fillcap_4
XFILLER_90_52 VDD VDD VSS VSS gf180mcu_fd_sc_mcu7t5v0__fill_1
XFILLER_31_769 VDD VDD VSS VSS gf180mcu_fd_sc_mcu7t5v0__fill_1
XFILLER_129_624 VDD VDD VSS VSS gf180mcu_fd_sc_mcu7t5v0__fillcap_4
XTAP_TAPCELL_ROW_13_455 VDD VSS gf180mcu_fd_sc_mcu7t5v0__filltie
XFILLER_30_257 VDD VDD VSS VSS gf180mcu_fd_sc_mcu7t5v0__fill_1
XFILLER_117_819 VDD VDD VSS VSS gf180mcu_fd_sc_mcu7t5v0__fillcap_16
XTAP_TAPCELL_ROW_96_1538 VDD VSS gf180mcu_fd_sc_mcu7t5v0__filltie
XFILLER_125_863 VDD VDD VSS VSS gf180mcu_fd_sc_mcu7t5v0__fillcap_32
X_3350_ _3902_/Q _3350_/A2 _4079_/D VDD VDD VSS VSS gf180mcu_fd_sc_mcu7t5v0__and2_1
XFILLER_124_373 VDD VDD VSS VSS gf180mcu_fd_sc_mcu7t5v0__fillcap_4
XFILLER_112_524 VDD VDD VSS VSS gf180mcu_fd_sc_mcu7t5v0__fill_1
X_2301_ _4097_/Q _3413_/A1 VDD VDD VSS VSS gf180mcu_fd_sc_mcu7t5v0__clkinv_1
XFILLER_97_268 VDD VDD VSS VSS gf180mcu_fd_sc_mcu7t5v0__fillcap_4
X_3281_ _3902_/Q _3281_/A2 _4065_/D VDD VDD VSS VSS gf180mcu_fd_sc_mcu7t5v0__and2_1
X_2232_ _3896_/Q place68/Z place63/Z _3944_/Q place67/Z _4088_/Q _2233_/A2 VDD VDD
+ VSS VSS gf180mcu_fd_sc_mcu7t5v0__aoi222_1
XFILLER_38_313 VDD VDD VSS VSS gf180mcu_fd_sc_mcu7t5v0__fill_2
Xclkbuf_leaf_2_clk clkbuf_leaf_5_clk/I clkload9/I VDD VDD VSS VSS gf180mcu_fd_sc_mcu7t5v0__clkbuf_8
XPHY_EDGE_ROW_119_Right_119 VDD VSS gf180mcu_fd_sc_mcu7t5v0__endcap
X_2163_ _4089_/Q _3394_/A3 _2216_/B1 _2170_/A2 VDD VDD VSS VSS gf180mcu_fd_sc_mcu7t5v0__nand3_1
XFILLER_17_2 VDD VDD VSS VSS gf180mcu_fd_sc_mcu7t5v0__fillcap_64
X_2094_ _2008_/Z _2094_/A2 _2094_/B _4146_/D VDD VDD VSS VSS gf180mcu_fd_sc_mcu7t5v0__oai21_4
XFILLER_54_839 VDD VDD VSS VSS gf180mcu_fd_sc_mcu7t5v0__fillcap_16
XTAP_TAPCELL_ROW_105_1656 VDD VSS gf180mcu_fd_sc_mcu7t5v0__filltie
XTAP_TAPCELL_ROW_105_1645 VDD VSS gf180mcu_fd_sc_mcu7t5v0__filltie
XFILLER_34_541 VDD VDD VSS VSS gf180mcu_fd_sc_mcu7t5v0__fill_1
XFILLER_53_349 VDD VDD VSS VSS gf180mcu_fd_sc_mcu7t5v0__fill_1
XFILLER_10_909 VDD VDD VSS VSS gf180mcu_fd_sc_mcu7t5v0__fillcap_16
X_1947_ _2895_/A1 _1947_/A2 _1947_/B _4143_/Q _1948_/B1 VDD VDD VSS VSS gf180mcu_fd_sc_mcu7t5v0__oai211_1
XFILLER_9_92 VDD VDD VSS VSS gf180mcu_fd_sc_mcu7t5v0__fill_2
X_1878_ _1878_/A1 _1878_/A2 _1878_/A3 _1884_/B VDD VDD VSS VSS gf180mcu_fd_sc_mcu7t5v0__nand3_1
X_3617_ _4063_/Q _3626_/A2 _3623_/A3 _3618_/S VDD VDD VSS VSS gf180mcu_fd_sc_mcu7t5v0__nand3_1
X_3548_ _3781_/Q _3789_/Q _3797_/Q _3805_/Q place76/Z place75/Z _3548_/Z VDD VDD VSS
+ VSS gf180mcu_fd_sc_mcu7t5v0__mux4_1
XFILLER_116_885 VDD VDD VSS VSS gf180mcu_fd_sc_mcu7t5v0__fillcap_4
XTAP_TAPCELL_ROW_116_1796 VDD VSS gf180mcu_fd_sc_mcu7t5v0__filltie
XFILLER_88_202 VDD VDD VSS VSS gf180mcu_fd_sc_mcu7t5v0__fillcap_4
XFILLER_1_629 VDD VDD VSS VSS gf180mcu_fd_sc_mcu7t5v0__fill_1
XFILLER_89_769 VDD VDD VSS VSS gf180mcu_fd_sc_mcu7t5v0__fill_1
X_3479_ _4107_/Q _3417_/Z _3463_/Z _3481_/B1 VDD VDD VSS VSS gf180mcu_fd_sc_mcu7t5v0__nand3_1
XFILLER_130_387 VDD VDD VSS VSS gf180mcu_fd_sc_mcu7t5v0__fillcap_16
XFILLER_96_290 VDD VDD VSS VSS gf180mcu_fd_sc_mcu7t5v0__fillcap_16
XFILLER_85_931 VDD VDD VSS VSS gf180mcu_fd_sc_mcu7t5v0__fill_2
XFILLER_29_346 VDD VDD VSS VSS gf180mcu_fd_sc_mcu7t5v0__fillcap_4
XFILLER_84_463 VDD VDD VSS VSS gf180mcu_fd_sc_mcu7t5v0__fill_1
XFILLER_53_850 VDD VDD VSS VSS gf180mcu_fd_sc_mcu7t5v0__fillcap_4
XTAP_TAPCELL_ROW_80_1328 VDD VSS gf180mcu_fd_sc_mcu7t5v0__filltie
XFILLER_13_758 VDD VDD VSS VSS gf180mcu_fd_sc_mcu7t5v0__fillcap_8
XFILLER_12_213 VDD VDD VSS VSS gf180mcu_fd_sc_mcu7t5v0__fill_2
XTAP_TAPCELL_ROW_10_414 VDD VSS gf180mcu_fd_sc_mcu7t5v0__filltie
XFILLER_121_2 VDD VDD VSS VSS gf180mcu_fd_sc_mcu7t5v0__fillcap_8
XFILLER_126_649 VDD VDD VSS VSS gf180mcu_fd_sc_mcu7t5v0__fill_1
XFILLER_125_137 VDD VDD VSS VSS gf180mcu_fd_sc_mcu7t5v0__fill_2
XFILLER_4_434 VDD VDD VSS VSS gf180mcu_fd_sc_mcu7t5v0__fillcap_4
XFILLER_60_99 VDD VDD VSS VSS gf180mcu_fd_sc_mcu7t5v0__fillcap_4
XFILLER_106_384 VDD VDD VSS VSS gf180mcu_fd_sc_mcu7t5v0__fill_1
XFILLER_69_53 VDD VDD VSS VSS gf180mcu_fd_sc_mcu7t5v0__fill_1
XFILLER_122_877 VDD VDD VSS VSS gf180mcu_fd_sc_mcu7t5v0__fillcap_4
XTAP_TAPCELL_ROW_91_1468 VDD VSS gf180mcu_fd_sc_mcu7t5v0__filltie
XFILLER_76_931 VDD VDD VSS VSS gf180mcu_fd_sc_mcu7t5v0__fill_2
XFILLER_90_422 VDD VDD VSS VSS gf180mcu_fd_sc_mcu7t5v0__fillcap_32
XTAP_TAPCELL_ROW_18_514 VDD VSS gf180mcu_fd_sc_mcu7t5v0__filltie
XTAP_TAPCELL_ROW_18_525 VDD VSS gf180mcu_fd_sc_mcu7t5v0__filltie
XFILLER_47_176 VDD VDD VSS VSS gf180mcu_fd_sc_mcu7t5v0__fillcap_32
XFILLER_63_636 VDD VDD VSS VSS gf180mcu_fd_sc_mcu7t5v0__fill_2
XFILLER_51_809 VDD VDD VSS VSS gf180mcu_fd_sc_mcu7t5v0__fill_2
XFILLER_63_669 VDD VDD VSS VSS gf180mcu_fd_sc_mcu7t5v0__fill_2
XTAP_TAPCELL_ROW_46_878 VDD VSS gf180mcu_fd_sc_mcu7t5v0__filltie
XTAP_TAPCELL_ROW_46_889 VDD VSS gf180mcu_fd_sc_mcu7t5v0__filltie
XFILLER_93_6 VDD VDD VSS VSS gf180mcu_fd_sc_mcu7t5v0__fill_2
X_2850_ place83/Z _3876_/Q _2850_/S _3876_/D VDD VDD VSS VSS gf180mcu_fd_sc_mcu7t5v0__mux2_2
X_1801_ _3895_/Q _3896_/Q _3893_/Q _3894_/Q _1935_/A1 VDD VDD VSS VSS gf180mcu_fd_sc_mcu7t5v0__nor4_2
XTAP_TAPCELL_ROW_100_1586 VDD VSS gf180mcu_fd_sc_mcu7t5v0__filltie
XFILLER_79_4 VDD VDD VSS VSS gf180mcu_fd_sc_mcu7t5v0__fill_1
XFILLER_129_476 VDD VDD VSS VSS gf180mcu_fd_sc_mcu7t5v0__fillcap_8
Xhold217 s_axi_wdata[29] hold217/Z VDD VDD VSS VSS gf180mcu_fd_sc_mcu7t5v0__dlyc_1
Xhold206 s_axi_wdata[11] hold206/Z VDD VDD VSS VSS gf180mcu_fd_sc_mcu7t5v0__dlyc_1
Xhold228 s_axi_wdata[23] hold228/Z VDD VDD VSS VSS gf180mcu_fd_sc_mcu7t5v0__dlyc_1
X_3402_ _4093_/Q _3402_/A2 _4093_/D VDD VDD VSS VSS gf180mcu_fd_sc_mcu7t5v0__xnor2_1
XFILLER_125_693 VDD VDD VSS VSS gf180mcu_fd_sc_mcu7t5v0__fillcap_4
XFILLER_98_522 VDD VDD VSS VSS gf180mcu_fd_sc_mcu7t5v0__fill_2
XFILLER_112_343 VDD VDD VSS VSS gf180mcu_fd_sc_mcu7t5v0__fillcap_32
X_3333_ _4081_/Q _3362_/A2 VDD VDD VSS VSS gf180mcu_fd_sc_mcu7t5v0__clkinv_1
XFILLER_59_909 VDD VDD VSS VSS gf180mcu_fd_sc_mcu7t5v0__fill_1
XPHY_EDGE_ROW_7_Right_7 VDD VSS gf180mcu_fd_sc_mcu7t5v0__endcap
X_3264_ _4062_/Q _3256_/Z _3263_/Z _3265_/B VDD VDD VSS VSS gf180mcu_fd_sc_mcu7t5v0__nor3_1
XFILLER_58_419 VDD VDD VSS VSS gf180mcu_fd_sc_mcu7t5v0__fillcap_8
X_2215_ _3908_/Q place72/Z _2217_/A2 VDD VDD VSS VSS gf180mcu_fd_sc_mcu7t5v0__nand2_1
XFILLER_38_132 VDD VDD VSS VSS gf180mcu_fd_sc_mcu7t5v0__fill_1
XFILLER_81_422 VDD VDD VSS VSS gf180mcu_fd_sc_mcu7t5v0__fillcap_64
X_2146_ _3655_/Q _3663_/Q _3671_/Q _3679_/Q place79/Z place78/Z _2146_/Z VDD VDD VSS
+ VSS gf180mcu_fd_sc_mcu7t5v0__mux4_1
X_2077_ _2008_/Z _2077_/A2 _2077_/B _4143_/D VDD VDD VSS VSS gf180mcu_fd_sc_mcu7t5v0__oai21_4
XFILLER_54_658 VDD VDD VSS VSS gf180mcu_fd_sc_mcu7t5v0__fillcap_4
XTAP_TAPCELL_ROW_66_1150 VDD VSS gf180mcu_fd_sc_mcu7t5v0__filltie
XFILLER_50_831 VDD VDD VSS VSS gf180mcu_fd_sc_mcu7t5v0__fill_2
XFILLER_14_37 VDD VDD VSS VSS gf180mcu_fd_sc_mcu7t5v0__fillcap_4
XFILLER_61_190 VDD VDD VSS VSS gf180mcu_fd_sc_mcu7t5v0__fillcap_16
X_2979_ _3934_/Q place89/Z _3041_/S _3934_/D VDD VDD VSS VSS gf180mcu_fd_sc_mcu7t5v0__mux2_2
XTAP_TAPCELL_ROW_118_1825 VDD VSS gf180mcu_fd_sc_mcu7t5v0__filltie
XTAP_TAPCELL_ROW_118_1814 VDD VSS gf180mcu_fd_sc_mcu7t5v0__filltie
XFILLER_107_137 VDD VDD VSS VSS gf180mcu_fd_sc_mcu7t5v0__fill_2
XPHY_EDGE_ROW_15_Left_148 VDD VSS gf180mcu_fd_sc_mcu7t5v0__endcap
XFILLER_30_69 VDD VDD VSS VSS gf180mcu_fd_sc_mcu7t5v0__fillcap_16
XFILLER_122_107 VDD VDD VSS VSS gf180mcu_fd_sc_mcu7t5v0__fillcap_64
XTAP_TAPCELL_ROW_77_1290 VDD VSS gf180mcu_fd_sc_mcu7t5v0__filltie
XFILLER_104_877 VDD VDD VSS VSS gf180mcu_fd_sc_mcu7t5v0__fillcap_16
XFILLER_130_195 VDD VDD VSS VSS gf180mcu_fd_sc_mcu7t5v0__fill_1
XFILLER_39_89 VDD VDD VSS VSS gf180mcu_fd_sc_mcu7t5v0__fillcap_4
XTAP_TAPCELL_ROW_129_1965 VDD VSS gf180mcu_fd_sc_mcu7t5v0__filltie
XFILLER_85_772 VDD VDD VSS VSS gf180mcu_fd_sc_mcu7t5v0__fillcap_64
XFILLER_73_912 VDD VDD VSS VSS gf180mcu_fd_sc_mcu7t5v0__fillcap_16
XFILLER_45_603 VDD VDD VSS VSS gf180mcu_fd_sc_mcu7t5v0__fillcap_16
XFILLER_69_290 VDD VDD VSS VSS gf180mcu_fd_sc_mcu7t5v0__fill_2
XFILLER_18_839 VDD VDD VSS VSS gf180mcu_fd_sc_mcu7t5v0__fillcap_4
XPHY_EDGE_ROW_24_Left_157 VDD VSS gf180mcu_fd_sc_mcu7t5v0__endcap
XFILLER_29_165 VDD VDD VSS VSS gf180mcu_fd_sc_mcu7t5v0__fillcap_4
XFILLER_44_102 VDD VDD VSS VSS gf180mcu_fd_sc_mcu7t5v0__fill_2
XFILLER_57_474 VDD VDD VSS VSS gf180mcu_fd_sc_mcu7t5v0__fill_2
XFILLER_13_500 VDD VDD VSS VSS gf180mcu_fd_sc_mcu7t5v0__fill_2
XFILLER_44_157 VDD VDD VSS VSS gf180mcu_fd_sc_mcu7t5v0__fill_1
XFILLER_111_72 VDD VDD VSS VSS gf180mcu_fd_sc_mcu7t5v0__fillcap_64
XFILLER_41_842 VDD VDD VSS VSS gf180mcu_fd_sc_mcu7t5v0__fillcap_16
XTAP_TAPCELL_ROW_43_848 VDD VSS gf180mcu_fd_sc_mcu7t5v0__filltie
XFILLER_40_341 VDD VDD VSS VSS gf180mcu_fd_sc_mcu7t5v0__fill_2
XFILLER_41_864 VDD VDD VSS VSS gf180mcu_fd_sc_mcu7t5v0__fill_1
XFILLER_71_54 VDD VDD VSS VSS gf180mcu_fd_sc_mcu7t5v0__fillcap_16
XFILLER_9_559 VDD VDD VSS VSS gf180mcu_fd_sc_mcu7t5v0__fill_1
XFILLER_9_548 VDD VDD VSS VSS gf180mcu_fd_sc_mcu7t5v0__fill_1
XTAP_TAPCELL_ROW_23_583 VDD VSS gf180mcu_fd_sc_mcu7t5v0__filltie
XFILLER_71_76 VDD VDD VSS VSS gf180mcu_fd_sc_mcu7t5v0__fill_2
XPHY_EDGE_ROW_33_Left_166 VDD VSS gf180mcu_fd_sc_mcu7t5v0__endcap
XFILLER_5_710 VDD VDD VSS VSS gf180mcu_fd_sc_mcu7t5v0__fill_1
XFILLER_126_457 VDD VDD VSS VSS gf180mcu_fd_sc_mcu7t5v0__fillcap_8
XFILLER_4_242 VDD VDD VSS VSS gf180mcu_fd_sc_mcu7t5v0__fill_2
XFILLER_68_717 VDD VDD VSS VSS gf180mcu_fd_sc_mcu7t5v0__fill_2
XFILLER_110_836 VDD VDD VSS VSS gf180mcu_fd_sc_mcu7t5v0__fillcap_32
XFILLER_96_84 VDD VDD VSS VSS gf180mcu_fd_sc_mcu7t5v0__fillcap_16
X_2000_ _4129_/Q _2001_/A1 VDD VDD VSS VSS gf180mcu_fd_sc_mcu7t5v0__inv_1
XPHY_EDGE_ROW_42_Left_175 VDD VSS gf180mcu_fd_sc_mcu7t5v0__endcap
XFILLER_64_901 VDD VDD VSS VSS gf180mcu_fd_sc_mcu7t5v0__fill_1
XFILLER_75_282 VDD VDD VSS VSS gf180mcu_fd_sc_mcu7t5v0__fillcap_16
XFILLER_63_422 VDD VDD VSS VSS gf180mcu_fd_sc_mcu7t5v0__fillcap_16
XFILLER_90_241 VDD VDD VSS VSS gf180mcu_fd_sc_mcu7t5v0__fillcap_4
X_3951_ _3951_/D _2279_/I _3978_/CLK _3951_/Q VDD VDD VSS VSS gf180mcu_fd_sc_mcu7t5v0__dffrnq_1
XFILLER_63_488 VDD VDD VSS VSS gf180mcu_fd_sc_mcu7t5v0__fill_2
X_2902_ _4035_/Q _2900_/S _2903_/B VDD VDD VSS VSS gf180mcu_fd_sc_mcu7t5v0__nand2_1
XTAP_TAPCELL_ROW_102_1615 VDD VSS gf180mcu_fd_sc_mcu7t5v0__filltie
XFILLER_31_341 VDD VDD VSS VSS gf180mcu_fd_sc_mcu7t5v0__fillcap_8
XFILLER_31_352 VDD VDD VSS VSS gf180mcu_fd_sc_mcu7t5v0__fillcap_32
X_3882_ _3882_/D _4057_/CLK _3882_/Q VDD VDD VSS VSS gf180mcu_fd_sc_mcu7t5v0__dffq_1
X_2833_ place83/Z _3868_/Q _2833_/S _3868_/D VDD VDD VSS VSS gf180mcu_fd_sc_mcu7t5v0__mux2_2
XPHY_EDGE_ROW_51_Left_184 VDD VSS gf180mcu_fd_sc_mcu7t5v0__endcap
X_2764_ _3836_/Q place83/Z _2764_/S _3836_/D VDD VDD VSS VSS gf180mcu_fd_sc_mcu7t5v0__mux2_2
XTAP_TAPCELL_ROW_61_1080 VDD VSS gf180mcu_fd_sc_mcu7t5v0__filltie
X_2695_ _3542_/A3 _2695_/A2 _2710_/S VDD VDD VSS VSS gf180mcu_fd_sc_mcu7t5v0__nand2_4
XFILLER_104_107 VDD VDD VSS VSS gf180mcu_fd_sc_mcu7t5v0__fillcap_8
XTAP_TAPCELL_ROW_113_1755 VDD VSS gf180mcu_fd_sc_mcu7t5v0__filltie
XFILLER_99_842 VDD VDD VSS VSS gf180mcu_fd_sc_mcu7t5v0__fillcap_16
XFILLER_99_897 VDD VDD VSS VSS gf180mcu_fd_sc_mcu7t5v0__fillcap_8
XFILLER_98_374 VDD VDD VSS VSS gf180mcu_fd_sc_mcu7t5v0__fillcap_8
X_3316_ _4080_/Q _3319_/B _3316_/Z VDD VDD VSS VSS gf180mcu_fd_sc_mcu7t5v0__xor2_1
XFILLER_113_696 VDD VDD VSS VSS gf180mcu_fd_sc_mcu7t5v0__fillcap_4
XFILLER_100_313 VDD VDD VSS VSS gf180mcu_fd_sc_mcu7t5v0__fill_2
XFILLER_86_547 VDD VDD VSS VSS gf180mcu_fd_sc_mcu7t5v0__fill_2
XPHY_EDGE_ROW_60_Left_193 VDD VSS gf180mcu_fd_sc_mcu7t5v0__endcap
XFILLER_132_27 VDD VDD VSS VSS gf180mcu_fd_sc_mcu7t5v0__fillcap_4
X_3247_ _4128_/D _3247_/A2 _4060_/D VDD VDD VSS VSS gf180mcu_fd_sc_mcu7t5v0__or2_1
XFILLER_73_208 VDD VDD VSS VSS gf180mcu_fd_sc_mcu7t5v0__fill_2
XFILLER_39_430 VDD VDD VSS VSS gf180mcu_fd_sc_mcu7t5v0__fillcap_4
XFILLER_27_614 VDD VDD VSS VSS gf180mcu_fd_sc_mcu7t5v0__fill_1
XFILLER_39_463 VDD VDD VSS VSS gf180mcu_fd_sc_mcu7t5v0__fillcap_16
XFILLER_54_411 VDD VDD VSS VSS gf180mcu_fd_sc_mcu7t5v0__fillcap_4
XFILLER_55_912 VDD VDD VSS VSS gf180mcu_fd_sc_mcu7t5v0__fillcap_16
XFILLER_67_772 VDD VDD VSS VSS gf180mcu_fd_sc_mcu7t5v0__fillcap_4
XFILLER_94_591 VDD VDD VSS VSS gf180mcu_fd_sc_mcu7t5v0__fillcap_4
XFILLER_82_753 VDD VDD VSS VSS gf180mcu_fd_sc_mcu7t5v0__fillcap_8
XFILLER_15_809 VDD VDD VSS VSS gf180mcu_fd_sc_mcu7t5v0__fillcap_16
X_2129_ _2125_/Z _2126_/Z _2127_/Z _2128_/Z place77/Z _4094_/Q _2129_/Z VDD VDD VSS
+ VSS gf180mcu_fd_sc_mcu7t5v0__mux4_1
XTAP_TAPCELL_ROW_124_1895 VDD VSS gf180mcu_fd_sc_mcu7t5v0__filltie
XFILLER_23_842 VDD VDD VSS VSS gf180mcu_fd_sc_mcu7t5v0__fillcap_16
XFILLER_25_69 VDD VDD VSS VSS gf180mcu_fd_sc_mcu7t5v0__fill_1
XFILLER_41_138 VDD VDD VSS VSS gf180mcu_fd_sc_mcu7t5v0__fill_2
XTAP_TAPCELL_ROW_40_807 VDD VSS gf180mcu_fd_sc_mcu7t5v0__filltie
XFILLER_50_661 VDD VDD VSS VSS gf180mcu_fd_sc_mcu7t5v0__fillcap_4
XFILLER_10_547 VDD VDD VSS VSS gf180mcu_fd_sc_mcu7t5v0__fill_2
XTAP_TAPCELL_ROW_20_542 VDD VSS gf180mcu_fd_sc_mcu7t5v0__filltie
XFILLER_108_402 VDD VDD VSS VSS gf180mcu_fd_sc_mcu7t5v0__fill_2
XFILLER_108_457 VDD VDD VSS VSS gf180mcu_fd_sc_mcu7t5v0__fillcap_64
XFILLER_124_928 VDD VDD VSS VSS gf180mcu_fd_sc_mcu7t5v0__fillcap_4
XFILLER_89_330 VDD VDD VSS VSS gf180mcu_fd_sc_mcu7t5v0__fillcap_4
XFILLER_89_341 VDD VDD VSS VSS gf180mcu_fd_sc_mcu7t5v0__fillcap_8
XFILLER_9_4 VDD VDD VSS VSS gf180mcu_fd_sc_mcu7t5v0__fill_1
XFILLER_1_212 VDD VDD VSS VSS gf180mcu_fd_sc_mcu7t5v0__fillcap_32
XFILLER_89_352 VDD VDD VSS VSS gf180mcu_fd_sc_mcu7t5v0__fillcap_32
XFILLER_2_779 VDD VDD VSS VSS gf180mcu_fd_sc_mcu7t5v0__fillcap_16
XFILLER_106_83 VDD VDD VSS VSS gf180mcu_fd_sc_mcu7t5v0__fill_2
XFILLER_46_901 VDD VDD VSS VSS gf180mcu_fd_sc_mcu7t5v0__fill_2
XTAP_TAPCELL_ROW_48_907 VDD VSS gf180mcu_fd_sc_mcu7t5v0__filltie
XFILLER_64_208 VDD VDD VSS VSS gf180mcu_fd_sc_mcu7t5v0__fillcap_32
XFILLER_57_282 VDD VDD VSS VSS gf180mcu_fd_sc_mcu7t5v0__fillcap_32
XTAP_TAPCELL_ROW_28_653 VDD VSS gf180mcu_fd_sc_mcu7t5v0__filltie
XFILLER_33_628 VDD VDD VSS VSS gf180mcu_fd_sc_mcu7t5v0__fill_2
XFILLER_13_352 VDD VDD VSS VSS gf180mcu_fd_sc_mcu7t5v0__fillcap_4
XFILLER_40_193 VDD VDD VSS VSS gf180mcu_fd_sc_mcu7t5v0__fillcap_8
XFILLER_127_755 VDD VDD VSS VSS gf180mcu_fd_sc_mcu7t5v0__fillcap_8
XFILLER_115_928 VDD VDD VSS VSS gf180mcu_fd_sc_mcu7t5v0__fillcap_4
XFILLER_5_562 VDD VDD VSS VSS gf180mcu_fd_sc_mcu7t5v0__fillcap_32
X_4150_ _4150_/D _4157_/RN _4156_/CLK _4150_/Q VDD VDD VSS VSS gf180mcu_fd_sc_mcu7t5v0__dffrnq_1
X_4081_ _4081_/D input92/Z _4163_/CLK _4081_/Q VDD VDD VSS VSS gf180mcu_fd_sc_mcu7t5v0__dffrnq_1
XFILLER_37_912 VDD VDD VSS VSS gf180mcu_fd_sc_mcu7t5v0__fillcap_16
XFILLER_49_772 VDD VDD VSS VSS gf180mcu_fd_sc_mcu7t5v0__fillcap_64
XFILLER_64_753 VDD VDD VSS VSS gf180mcu_fd_sc_mcu7t5v0__fillcap_32
XFILLER_23_138 VDD VDD VSS VSS gf180mcu_fd_sc_mcu7t5v0__fill_2
XFILLER_51_414 VDD VDD VSS VSS gf180mcu_fd_sc_mcu7t5v0__fillcap_4
X_3934_ _3934_/D _4157_/RN _4127_/CLK _3934_/Q VDD VDD VSS VSS gf180mcu_fd_sc_mcu7t5v0__dffrnq_1
XFILLER_20_801 VDD VDD VSS VSS gf180mcu_fd_sc_mcu7t5v0__fillcap_4
X_3865_ _3865_/D _3865_/CLK _3865_/Q VDD VDD VSS VSS gf180mcu_fd_sc_mcu7t5v0__dffq_1
X_2816_ place83/Z _3860_/Q _2816_/S _3860_/D VDD VDD VSS VSS gf180mcu_fd_sc_mcu7t5v0__mux2_2
XFILLER_118_733 VDD VDD VSS VSS gf180mcu_fd_sc_mcu7t5v0__fill_2
X_3796_ _3796_/D clkload8/I _3796_/Q VDD VDD VSS VSS gf180mcu_fd_sc_mcu7t5v0__dffq_1
XFILLER_127_38 VDD VDD VSS VSS gf180mcu_fd_sc_mcu7t5v0__fillcap_32
XFILLER_118_788 VDD VDD VSS VSS gf180mcu_fd_sc_mcu7t5v0__fill_2
XFILLER_117_276 VDD VDD VSS VSS gf180mcu_fd_sc_mcu7t5v0__fillcap_4
X_2678_ _2801_/A1 _2695_/A2 _2693_/S VDD VDD VSS VSS gf180mcu_fd_sc_mcu7t5v0__nand2_4
XFILLER_105_438 VDD VDD VSS VSS gf180mcu_fd_sc_mcu7t5v0__fill_1
XFILLER_99_661 VDD VDD VSS VSS gf180mcu_fd_sc_mcu7t5v0__fill_1
XFILLER_87_856 VDD VDD VSS VSS gf180mcu_fd_sc_mcu7t5v0__fill_1
XTAP_TAPCELL_ROW_6_359 VDD VSS gf180mcu_fd_sc_mcu7t5v0__filltie
XFILLER_59_547 VDD VDD VSS VSS gf180mcu_fd_sc_mcu7t5v0__fillcap_8
XFILLER_46_208 VDD VDD VSS VSS gf180mcu_fd_sc_mcu7t5v0__fillcap_4
XTAP_TAPCELL_ROW_126_1924 VDD VSS gf180mcu_fd_sc_mcu7t5v0__filltie
XFILLER_27_422 VDD VDD VSS VSS gf180mcu_fd_sc_mcu7t5v0__fillcap_8
XTAP_TAPCELL_ROW_25_612 VDD VSS gf180mcu_fd_sc_mcu7t5v0__filltie
XFILLER_30_609 VDD VDD VSS VSS gf180mcu_fd_sc_mcu7t5v0__fillcap_4
XTAP_TAPCELL_ROW_53_976 VDD VSS gf180mcu_fd_sc_mcu7t5v0__filltie
XFILLER_23_672 VDD VDD VSS VSS gf180mcu_fd_sc_mcu7t5v0__fill_2
XFILLER_52_34 VDD VDD VSS VSS gf180mcu_fd_sc_mcu7t5v0__fill_1
XFILLER_11_889 VDD VDD VSS VSS gf180mcu_fd_sc_mcu7t5v0__fillcap_16
XFILLER_123_202 VDD VDD VSS VSS gf180mcu_fd_sc_mcu7t5v0__fillcap_8
XFILLER_109_788 VDD VDD VSS VSS gf180mcu_fd_sc_mcu7t5v0__fillcap_8
XPHY_EDGE_ROW_107_Left_240 VDD VSS gf180mcu_fd_sc_mcu7t5v0__endcap
XFILLER_124_769 VDD VDD VSS VSS gf180mcu_fd_sc_mcu7t5v0__fillcap_8
XFILLER_112_909 VDD VDD VSS VSS gf180mcu_fd_sc_mcu7t5v0__fillcap_16
XFILLER_123_279 VDD VDD VSS VSS gf180mcu_fd_sc_mcu7t5v0__fill_1
XFILLER_111_419 VDD VDD VSS VSS gf180mcu_fd_sc_mcu7t5v0__fill_1
XFILLER_78_801 VDD VDD VSS VSS gf180mcu_fd_sc_mcu7t5v0__fillcap_4
XFILLER_120_931 VDD VDD VSS VSS gf180mcu_fd_sc_mcu7t5v0__fill_2
XTAP_TAPCELL_ROW_88_1429 VDD VSS gf180mcu_fd_sc_mcu7t5v0__filltie
XFILLER_19_912 VDD VDD VSS VSS gf180mcu_fd_sc_mcu7t5v0__fillcap_16
XFILLER_46_753 VDD VDD VSS VSS gf180mcu_fd_sc_mcu7t5v0__fillcap_8
X_1980_ _3391_/B _3968_/Q _1993_/A1 VDD VDD VSS VSS gf180mcu_fd_sc_mcu7t5v0__nor2_1
XFILLER_14_661 VDD VDD VSS VSS gf180mcu_fd_sc_mcu7t5v0__fillcap_4
XFILLER_20_119 VDD VDD VSS VSS gf180mcu_fd_sc_mcu7t5v0__fill_2
XFILLER_9_142 VDD VDD VSS VSS gf180mcu_fd_sc_mcu7t5v0__fillcap_32
XTAP_TAPCELL_ROW_99_1569 VDD VSS gf180mcu_fd_sc_mcu7t5v0__filltie
X_3650_ _3650_/D _4094_/CLK _3650_/Q VDD VDD VSS VSS gf180mcu_fd_sc_mcu7t5v0__dffq_1
X_3581_ _3762_/Q _3818_/Q _3826_/Q _3834_/Q _4116_/Q place75/Z _3581_/Z VDD VDD VSS
+ VSS gf180mcu_fd_sc_mcu7t5v0__mux4_1
X_2601_ _4122_/Q _2642_/A2 _2852_/A1 VDD VDD VSS VSS gf180mcu_fd_sc_mcu7t5v0__nor2_2
XFILLER_127_574 VDD VDD VSS VSS gf180mcu_fd_sc_mcu7t5v0__fill_1
X_2532_ _4071_/Q _3737_/Q _2538_/S _3737_/D VDD VDD VSS VSS gf180mcu_fd_sc_mcu7t5v0__mux2_2
XFILLER_5_381 VDD VDD VSS VSS gf180mcu_fd_sc_mcu7t5v0__fillcap_16
XTAP_TAPCELL_ROW_110_1714 VDD VSS gf180mcu_fd_sc_mcu7t5v0__filltie
XFILLER_47_2 VDD VDD VSS VSS gf180mcu_fd_sc_mcu7t5v0__fillcap_32
X_4133_ _4133_/D _4148_/RN _4136_/CLK _4133_/Q VDD VDD VSS VSS gf180mcu_fd_sc_mcu7t5v0__dffrnq_1
XFILLER_3_72 VDD VDD VSS VSS gf180mcu_fd_sc_mcu7t5v0__fillcap_8
XFILLER_68_333 VDD VDD VSS VSS gf180mcu_fd_sc_mcu7t5v0__fillcap_8
X_4064_ _4064_/D input92/Z _4163_/CLK _4064_/Q VDD VDD VSS VSS gf180mcu_fd_sc_mcu7t5v0__dffrnq_1
XTAP_TAPCELL_ROW_3_329 VDD VSS gf180mcu_fd_sc_mcu7t5v0__filltie
XFILLER_68_399 VDD VDD VSS VSS gf180mcu_fd_sc_mcu7t5v0__fill_2
XFILLER_83_358 VDD VDD VSS VSS gf180mcu_fd_sc_mcu7t5v0__fill_1
XTAP_TAPCELL_ROW_108_1687 VDD VSS gf180mcu_fd_sc_mcu7t5v0__filltie
XFILLER_92_892 VDD VDD VSS VSS gf180mcu_fd_sc_mcu7t5v0__fill_2
XFILLER_91_380 VDD VDD VSS VSS gf180mcu_fd_sc_mcu7t5v0__fillcap_32
XFILLER_52_734 VDD VDD VSS VSS gf180mcu_fd_sc_mcu7t5v0__fill_1
XFILLER_12_609 VDD VDD VSS VSS gf180mcu_fd_sc_mcu7t5v0__fill_1
XTAP_TAPCELL_ROW_121_1865 VDD VSS gf180mcu_fd_sc_mcu7t5v0__filltie
XTAP_TAPCELL_ROW_121_1854 VDD VSS gf180mcu_fd_sc_mcu7t5v0__filltie
XTAP_TAPCELL_ROW_50_935 VDD VSS gf180mcu_fd_sc_mcu7t5v0__filltie
X_3917_ _3917_/D _4157_/RN _3975_/CLK _3917_/Q VDD VDD VSS VSS gf180mcu_fd_sc_mcu7t5v0__dffrnq_1
X_3848_ _3848_/D _3864_/CLK _3848_/Q VDD VDD VSS VSS gf180mcu_fd_sc_mcu7t5v0__dffq_1
XFILLER_20_675 VDD VDD VSS VSS gf180mcu_fd_sc_mcu7t5v0__fill_2
XFILLER_22_37 VDD VDD VSS VSS gf180mcu_fd_sc_mcu7t5v0__fill_2
XTAP_TAPCELL_ROW_30_670 VDD VSS gf180mcu_fd_sc_mcu7t5v0__filltie
XTAP_TAPCELL_ROW_30_681 VDD VSS gf180mcu_fd_sc_mcu7t5v0__filltie
X_3779_ _3779_/D _4023_/CLK _3779_/Q VDD VDD VSS VSS gf180mcu_fd_sc_mcu7t5v0__dffq_1
XFILLER_0_8 VDD VDD VSS VSS gf180mcu_fd_sc_mcu7t5v0__fill_1
XTAP_TAPCELL_ROW_72_1219 VDD VSS gf180mcu_fd_sc_mcu7t5v0__filltie
XFILLER_120_227 VDD VDD VSS VSS gf180mcu_fd_sc_mcu7t5v0__fill_1
XFILLER_47_34 VDD VDD VSS VSS gf180mcu_fd_sc_mcu7t5v0__fillcap_8
XFILLER_74_347 VDD VDD VSS VSS gf180mcu_fd_sc_mcu7t5v0__fillcap_8
XFILLER_28_731 VDD VDD VSS VSS gf180mcu_fd_sc_mcu7t5v0__fillcap_4
XFILLER_27_241 VDD VDD VSS VSS gf180mcu_fd_sc_mcu7t5v0__fillcap_32
XFILLER_28_753 VDD VDD VSS VSS gf180mcu_fd_sc_mcu7t5v0__fill_2
XFILLER_62_509 VDD VDD VSS VSS gf180mcu_fd_sc_mcu7t5v0__fill_1
XTAP_TAPCELL_ROW_38_781 VDD VSS gf180mcu_fd_sc_mcu7t5v0__filltie
XTAP_TAPCELL_ROW_83_1359 VDD VSS gf180mcu_fd_sc_mcu7t5v0__filltie
XFILLER_43_767 VDD VDD VSS VSS gf180mcu_fd_sc_mcu7t5v0__fill_2
XFILLER_63_66 VDD VDD VSS VSS gf180mcu_fd_sc_mcu7t5v0__fillcap_4
XFILLER_70_597 VDD VDD VSS VSS gf180mcu_fd_sc_mcu7t5v0__fillcap_8
XFILLER_11_675 VDD VDD VSS VSS gf180mcu_fd_sc_mcu7t5v0__fillcap_4
XFILLER_7_602 VDD VDD VSS VSS gf180mcu_fd_sc_mcu7t5v0__fillcap_4
XFILLER_10_174 VDD VDD VSS VSS gf180mcu_fd_sc_mcu7t5v0__fill_1
XFILLER_3_830 VDD VDD VSS VSS gf180mcu_fd_sc_mcu7t5v0__fillcap_8
XFILLER_97_406 VDD VDD VSS VSS gf180mcu_fd_sc_mcu7t5v0__fillcap_8
XFILLER_88_85 VDD VDD VSS VSS gf180mcu_fd_sc_mcu7t5v0__fillcap_16
XFILLER_81_829 VDD VDD VSS VSS gf180mcu_fd_sc_mcu7t5v0__fillcap_8
XFILLER_18_241 VDD VDD VSS VSS gf180mcu_fd_sc_mcu7t5v0__fillcap_4
XFILLER_92_177 VDD VDD VSS VSS gf180mcu_fd_sc_mcu7t5v0__fill_1
XFILLER_80_317 VDD VDD VSS VSS gf180mcu_fd_sc_mcu7t5v0__fillcap_8
XTAP_TAPCELL_ROW_16_497 VDD VSS gf180mcu_fd_sc_mcu7t5v0__filltie
X_1894_ _1897_/A1 _1935_/A4 _1910_/S VDD VDD VSS VSS gf180mcu_fd_sc_mcu7t5v0__nand2_1
X_3702_ _3702_/D _4072_/CLK _3702_/Q VDD VDD VSS VSS gf180mcu_fd_sc_mcu7t5v0__dffq_1
XFILLER_119_349 VDD VDD VSS VSS gf180mcu_fd_sc_mcu7t5v0__fill_1
X_3633_ _3633_/D _3729_/CLK _3633_/Q VDD VDD VSS VSS gf180mcu_fd_sc_mcu7t5v0__dffq_1
X_3564_ _3560_/Z _3561_/Z _3562_/Z _3563_/Z place74/Z _4119_/Q _3564_/Z VDD VDD VSS
+ VSS gf180mcu_fd_sc_mcu7t5v0__mux4_1
XTAP_TAPCELL_ROW_58_1041 VDD VSS gf180mcu_fd_sc_mcu7t5v0__filltie
X_3495_ _4104_/Q _4109_/Q _3495_/B _3496_/C VDD VDD VSS VSS gf180mcu_fd_sc_mcu7t5v0__aoi21_1
X_2515_ _3729_/Q _4071_/Q _2521_/S _3729_/D VDD VDD VSS VSS gf180mcu_fd_sc_mcu7t5v0__mux2_2
X_2446_ _3699_/Q _4073_/Q _2448_/S _3699_/D VDD VDD VSS VSS gf180mcu_fd_sc_mcu7t5v0__mux2_2
XFILLER_130_569 VDD VDD VSS VSS gf180mcu_fd_sc_mcu7t5v0__fillcap_16
XFILLER_111_772 VDD VDD VSS VSS gf180mcu_fd_sc_mcu7t5v0__fillcap_16
X_2377_ _3668_/Q _4074_/Q _2377_/S _3668_/D VDD VDD VSS VSS gf180mcu_fd_sc_mcu7t5v0__mux2_2
X_4116_ _4116_/D _2279_/I _4148_/CLK _4116_/Q VDD VDD VSS VSS gf180mcu_fd_sc_mcu7t5v0__dffrnq_2
XFILLER_84_645 VDD VDD VSS VSS gf180mcu_fd_sc_mcu7t5v0__fillcap_8
X_4047_ _4047_/D _4148_/RN _4136_/CLK _4047_/Q VDD VDD VSS VSS gf180mcu_fd_sc_mcu7t5v0__dffrnq_1
XFILLER_72_807 VDD VDD VSS VSS gf180mcu_fd_sc_mcu7t5v0__fillcap_16
XTAP_TAPCELL_ROW_69_1181 VDD VSS gf180mcu_fd_sc_mcu7t5v0__filltie
XFILLER_80_851 VDD VDD VSS VSS gf180mcu_fd_sc_mcu7t5v0__fillcap_16
XTAP_TAPCELL_ROW_35_740 VDD VSS gf180mcu_fd_sc_mcu7t5v0__filltie
XFILLER_40_737 VDD VDD VSS VSS gf180mcu_fd_sc_mcu7t5v0__fillcap_32
XFILLER_52_597 VDD VDD VSS VSS gf180mcu_fd_sc_mcu7t5v0__fillcap_32
XFILLER_123_6 VDD VDD VSS VSS gf180mcu_fd_sc_mcu7t5v0__fill_2
XFILLER_106_522 VDD VDD VSS VSS gf180mcu_fd_sc_mcu7t5v0__fill_2
XFILLER_3_115 VDD VDD VSS VSS gf180mcu_fd_sc_mcu7t5v0__fillcap_16
XFILLER_121_569 VDD VDD VSS VSS gf180mcu_fd_sc_mcu7t5v0__fillcap_16
XFILLER_58_33 VDD VDD VSS VSS gf180mcu_fd_sc_mcu7t5v0__fill_2
XFILLER_59_130 VDD VDD VSS VSS gf180mcu_fd_sc_mcu7t5v0__fillcap_8
XFILLER_75_601 VDD VDD VSS VSS gf180mcu_fd_sc_mcu7t5v0__fillcap_16
XFILLER_101_282 VDD VDD VSS VSS gf180mcu_fd_sc_mcu7t5v0__fillcap_32
XFILLER_75_634 VDD VDD VSS VSS gf180mcu_fd_sc_mcu7t5v0__fill_1
XFILLER_74_111 VDD VDD VSS VSS gf180mcu_fd_sc_mcu7t5v0__fill_2
XFILLER_47_314 VDD VDD VSS VSS gf180mcu_fd_sc_mcu7t5v0__fillcap_8
XFILLER_62_306 VDD VDD VSS VSS gf180mcu_fd_sc_mcu7t5v0__fillcap_8
XFILLER_16_734 VDD VDD VSS VSS gf180mcu_fd_sc_mcu7t5v0__fill_1
XFILLER_28_594 VDD VDD VSS VSS gf180mcu_fd_sc_mcu7t5v0__fill_1
XFILLER_62_317 VDD VDD VSS VSS gf180mcu_fd_sc_mcu7t5v0__fillcap_8
XFILLER_129_636 VDD VDD VSS VSS gf180mcu_fd_sc_mcu7t5v0__fill_2
XTAP_TAPCELL_ROW_13_456 VDD VSS gf180mcu_fd_sc_mcu7t5v0__filltie
XFILLER_30_247 VDD VDD VSS VSS gf180mcu_fd_sc_mcu7t5v0__fillcap_8
XFILLER_8_933 VDD VDD VSS VSS gf180mcu_fd_sc_mcu7t5v0__fill_1
XTAP_TAPCELL_ROW_96_1539 VDD VSS gf180mcu_fd_sc_mcu7t5v0__filltie
XTAP_TAPCELL_ROW_96_1528 VDD VSS gf180mcu_fd_sc_mcu7t5v0__filltie
XFILLER_7_454 VDD VDD VSS VSS gf180mcu_fd_sc_mcu7t5v0__fillcap_16
XFILLER_125_842 VDD VDD VSS VSS gf180mcu_fd_sc_mcu7t5v0__fillcap_4
XFILLER_109_382 VDD VDD VSS VSS gf180mcu_fd_sc_mcu7t5v0__fill_1
Xaz_v_uart_top s_axi_bresp[0] VDD VDD VSS VSS gf180mcu_fd_sc_mcu7t5v0__tiel
X_2300_ _4096_/Q _3407_/A2 _2300_/A3 _2505_/A1 VDD VDD VSS VSS gf180mcu_fd_sc_mcu7t5v0__nand3_1
X_3280_ _3340_/A2 _3280_/A2 _3627_/I1 _3280_/B _3281_/A2 VDD VDD VSS VSS gf180mcu_fd_sc_mcu7t5v0__oai31_1
X_2231_ _3912_/Q place72/Z _2233_/A1 VDD VDD VSS VSS gf180mcu_fd_sc_mcu7t5v0__nand2_1
XFILLER_78_472 VDD VDD VSS VSS gf180mcu_fd_sc_mcu7t5v0__fill_2
X_2162_ _3375_/A2 _2161_/Z _2170_/A1 VDD VDD VSS VSS gf180mcu_fd_sc_mcu7t5v0__nand2_1
X_2093_ place52/Z _2093_/A2 _2094_/B VDD VDD VSS VSS gf180mcu_fd_sc_mcu7t5v0__nand2_1
XFILLER_38_369 VDD VDD VSS VSS gf180mcu_fd_sc_mcu7t5v0__fillcap_16
XFILLER_54_807 VDD VDD VSS VSS gf180mcu_fd_sc_mcu7t5v0__fillcap_32
XFILLER_66_667 VDD VDD VSS VSS gf180mcu_fd_sc_mcu7t5v0__fillcap_64
XFILLER_93_486 VDD VDD VSS VSS gf180mcu_fd_sc_mcu7t5v0__fillcap_4
XFILLER_81_626 VDD VDD VSS VSS gf180mcu_fd_sc_mcu7t5v0__fillcap_4
XFILLER_65_166 VDD VDD VSS VSS gf180mcu_fd_sc_mcu7t5v0__fillcap_4
XFILLER_65_199 VDD VDD VSS VSS gf180mcu_fd_sc_mcu7t5v0__fillcap_8
XTAP_TAPCELL_ROW_105_1646 VDD VSS gf180mcu_fd_sc_mcu7t5v0__filltie
XTAP_TAPCELL_ROW_105_1657 VDD VSS gf180mcu_fd_sc_mcu7t5v0__filltie
XFILLER_21_214 VDD VDD VSS VSS gf180mcu_fd_sc_mcu7t5v0__fill_1
XFILLER_22_737 VDD VDD VSS VSS gf180mcu_fd_sc_mcu7t5v0__fillcap_8
XFILLER_34_597 VDD VDD VSS VSS gf180mcu_fd_sc_mcu7t5v0__fillcap_64
X_2995_ _3942_/Q _4030_/Q _3041_/S _3942_/D VDD VDD VSS VSS gf180mcu_fd_sc_mcu7t5v0__mux2_2
X_1946_ _2895_/A1 _1907_/C _4142_/Q _1948_/A2 VDD VDD VSS VSS gf180mcu_fd_sc_mcu7t5v0__oai21_1
XFILLER_30_770 VDD VDD VSS VSS gf180mcu_fd_sc_mcu7t5v0__fill_2
XFILLER_107_308 VDD VDD VSS VSS gf180mcu_fd_sc_mcu7t5v0__fillcap_16
X_1877_ _1892_/B _3890_/Q _4137_/Q _1935_/A4 _1878_/A3 VDD VDD VSS VSS gf180mcu_fd_sc_mcu7t5v0__nand4_1
XFILLER_115_352 VDD VDD VSS VSS gf180mcu_fd_sc_mcu7t5v0__fillcap_64
X_3547_ _3869_/Q _3877_/Q _3765_/Q _3773_/Q place76/Z place75/Z _3547_/Z VDD VDD VSS
+ VSS gf180mcu_fd_sc_mcu7t5v0__mux4_1
XFILLER_130_311 VDD VDD VSS VSS gf180mcu_fd_sc_mcu7t5v0__fillcap_4
XTAP_TAPCELL_ROW_116_1797 VDD VSS gf180mcu_fd_sc_mcu7t5v0__filltie
XFILLER_88_247 VDD VDD VSS VSS gf180mcu_fd_sc_mcu7t5v0__fillcap_64
X_3478_ _4104_/Q _3478_/A2 _3478_/B _3481_/A2 VDD VDD VSS VSS gf180mcu_fd_sc_mcu7t5v0__oai21_1
XFILLER_69_450 VDD VDD VSS VSS gf180mcu_fd_sc_mcu7t5v0__fill_2
XFILLER_84_475 VDD VDD VSS VSS gf180mcu_fd_sc_mcu7t5v0__fillcap_4
XFILLER_38_870 VDD VDD VSS VSS gf180mcu_fd_sc_mcu7t5v0__fillcap_4
XFILLER_44_317 VDD VDD VSS VSS gf180mcu_fd_sc_mcu7t5v0__fillcap_8
XFILLER_56_177 VDD VDD VSS VSS gf180mcu_fd_sc_mcu7t5v0__fillcap_64
XFILLER_13_726 VDD VDD VSS VSS gf180mcu_fd_sc_mcu7t5v0__fill_1
XTAP_TAPCELL_ROW_80_1329 VDD VSS gf180mcu_fd_sc_mcu7t5v0__filltie
XFILLER_12_247 VDD VDD VSS VSS gf180mcu_fd_sc_mcu7t5v0__fillcap_64
XFILLER_40_567 VDD VDD VSS VSS gf180mcu_fd_sc_mcu7t5v0__fillcap_16
XTAP_TAPCELL_ROW_10_415 VDD VSS gf180mcu_fd_sc_mcu7t5v0__filltie
XFILLER_60_45 VDD VDD VSS VSS gf180mcu_fd_sc_mcu7t5v0__fillcap_4
XFILLER_119_680 VDD VDD VSS VSS gf180mcu_fd_sc_mcu7t5v0__fill_1
XFILLER_109_50 VDD VDD VSS VSS gf180mcu_fd_sc_mcu7t5v0__fill_2
XFILLER_122_801 VDD VDD VSS VSS gf180mcu_fd_sc_mcu7t5v0__fillcap_4
XFILLER_109_72 VDD VDD VSS VSS gf180mcu_fd_sc_mcu7t5v0__fillcap_16
XFILLER_4_457 VDD VDD VSS VSS gf180mcu_fd_sc_mcu7t5v0__fillcap_16
XFILLER_69_43 VDD VDD VSS VSS gf180mcu_fd_sc_mcu7t5v0__fillcap_8
XTAP_TAPCELL_ROW_91_1469 VDD VSS gf180mcu_fd_sc_mcu7t5v0__filltie
XFILLER_36_807 VDD VDD VSS VSS gf180mcu_fd_sc_mcu7t5v0__fillcap_16
XFILLER_48_667 VDD VDD VSS VSS gf180mcu_fd_sc_mcu7t5v0__fillcap_64
XTAP_TAPCELL_ROW_18_515 VDD VSS gf180mcu_fd_sc_mcu7t5v0__filltie
XFILLER_62_103 VDD VDD VSS VSS gf180mcu_fd_sc_mcu7t5v0__fill_2
XFILLER_63_626 VDD VDD VSS VSS gf180mcu_fd_sc_mcu7t5v0__fillcap_4
XTAP_TAPCELL_ROW_18_526 VDD VSS gf180mcu_fd_sc_mcu7t5v0__filltie
XFILLER_90_467 VDD VDD VSS VSS gf180mcu_fd_sc_mcu7t5v0__fill_1
XTAP_TAPCELL_ROW_46_879 VDD VSS gf180mcu_fd_sc_mcu7t5v0__filltie
XFILLER_16_597 VDD VDD VSS VSS gf180mcu_fd_sc_mcu7t5v0__fillcap_16
XFILLER_43_372 VDD VDD VSS VSS gf180mcu_fd_sc_mcu7t5v0__fill_2
XFILLER_44_895 VDD VDD VSS VSS gf180mcu_fd_sc_mcu7t5v0__fill_1
XFILLER_129_400 VDD VDD VSS VSS gf180mcu_fd_sc_mcu7t5v0__fillcap_4
X_1800_ _3899_/Q _3900_/Q _2013_/A1 VDD VDD VSS VSS gf180mcu_fd_sc_mcu7t5v0__nor2_1
XFILLER_129_422 VDD VDD VSS VSS gf180mcu_fd_sc_mcu7t5v0__fill_2
X_2780_ place84/Z _3843_/Q _2782_/S _3843_/D VDD VDD VSS VSS gf180mcu_fd_sc_mcu7t5v0__mux2_2
XTAP_TAPCELL_ROW_100_1587 VDD VSS gf180mcu_fd_sc_mcu7t5v0__filltie
XFILLER_129_488 VDD VDD VSS VSS gf180mcu_fd_sc_mcu7t5v0__fill_2
XFILLER_116_127 VDD VDD VSS VSS gf180mcu_fd_sc_mcu7t5v0__fillcap_4
Xhold207 s_axi_wdata[12] hold207/Z VDD VDD VSS VSS gf180mcu_fd_sc_mcu7t5v0__dlyc_1
Xhold218 s_axi_wdata[27] hold218/Z VDD VDD VSS VSS gf180mcu_fd_sc_mcu7t5v0__dlyc_1
Xhold229 s_axi_wdata[22] hold229/Z VDD VDD VSS VSS gf180mcu_fd_sc_mcu7t5v0__dlyc_1
X_3401_ place78/Z place79/Z _3372_/Z _3402_/A2 VDD VDD VSS VSS gf180mcu_fd_sc_mcu7t5v0__nand3_1
XTAP_TAPCELL_ROW_55_1000 VDD VSS gf180mcu_fd_sc_mcu7t5v0__filltie
X_3332_ _3332_/A1 _3332_/A2 _3337_/A1 _3332_/B2 _4076_/D VDD VDD VSS VSS gf180mcu_fd_sc_mcu7t5v0__aoi22_2
XFILLER_112_333 VDD VDD VSS VSS gf180mcu_fd_sc_mcu7t5v0__fillcap_4
XFILLER_85_206 VDD VDD VSS VSS gf180mcu_fd_sc_mcu7t5v0__fillcap_4
X_3263_ _3607_/A3 _3263_/A2 _3263_/Z VDD VDD VSS VSS gf180mcu_fd_sc_mcu7t5v0__or2_1
X_3194_ _4036_/Q _4004_/Q _4129_/D _4036_/D VDD VDD VSS VSS gf180mcu_fd_sc_mcu7t5v0__mux2_2
X_2214_ _3375_/A2 _2213_/Z _2217_/A1 VDD VDD VSS VSS gf180mcu_fd_sc_mcu7t5v0__nand2_1
XFILLER_67_932 VDD VDD VSS VSS gf180mcu_fd_sc_mcu7t5v0__fill_2
XFILLER_94_773 VDD VDD VSS VSS gf180mcu_fd_sc_mcu7t5v0__fill_1
XFILLER_38_122 VDD VDD VSS VSS gf180mcu_fd_sc_mcu7t5v0__fillcap_8
X_2145_ _3743_/Q _3751_/Q _3639_/Q _3647_/Q place79/Z place78/Z _2145_/Z VDD VDD VSS
+ VSS gf180mcu_fd_sc_mcu7t5v0__mux4_1
XFILLER_66_453 VDD VDD VSS VSS gf180mcu_fd_sc_mcu7t5v0__fill_2
XFILLER_54_637 VDD VDD VSS VSS gf180mcu_fd_sc_mcu7t5v0__fillcap_4
X_2076_ place71/Z place52/Z _2074_/Z _2077_/B VDD VDD VSS VSS gf180mcu_fd_sc_mcu7t5v0__nand3_1
XFILLER_93_294 VDD VDD VSS VSS gf180mcu_fd_sc_mcu7t5v0__fillcap_4
XFILLER_19_380 VDD VDD VSS VSS gf180mcu_fd_sc_mcu7t5v0__fillcap_4
Xclkbuf_3_5__f_clk clkbuf_0_clk/Z clkload4/I VDD VDD VSS VSS gf180mcu_fd_sc_mcu7t5v0__clkbuf_16
XTAP_TAPCELL_ROW_66_1140 VDD VSS gf180mcu_fd_sc_mcu7t5v0__filltie
XFILLER_14_27 VDD VDD VSS VSS gf180mcu_fd_sc_mcu7t5v0__fillcap_8
XFILLER_22_523 VDD VDD VSS VSS gf180mcu_fd_sc_mcu7t5v0__fill_2
XFILLER_34_383 VDD VDD VSS VSS gf180mcu_fd_sc_mcu7t5v0__fill_2
XTAP_TAPCELL_ROW_118_1826 VDD VSS gf180mcu_fd_sc_mcu7t5v0__filltie
XTAP_TAPCELL_ROW_118_1815 VDD VSS gf180mcu_fd_sc_mcu7t5v0__filltie
X_1929_ _2895_/A1 _1947_/A2 _1920_/Z _1930_/B VDD VDD VSS VSS gf180mcu_fd_sc_mcu7t5v0__nand3_1
XFILLER_116_661 VDD VDD VSS VSS gf180mcu_fd_sc_mcu7t5v0__fillcap_4
XTAP_TAPCELL_ROW_77_1291 VDD VSS gf180mcu_fd_sc_mcu7t5v0__filltie
XFILLER_115_182 VDD VDD VSS VSS gf180mcu_fd_sc_mcu7t5v0__fillcap_16
XFILLER_89_556 VDD VDD VSS VSS gf180mcu_fd_sc_mcu7t5v0__fillcap_4
XFILLER_1_438 VDD VDD VSS VSS gf180mcu_fd_sc_mcu7t5v0__fill_2
XFILLER_29_100 VDD VDD VSS VSS gf180mcu_fd_sc_mcu7t5v0__fill_2
XTAP_TAPCELL_ROW_129_1966 VDD VSS gf180mcu_fd_sc_mcu7t5v0__filltie
XFILLER_18_807 VDD VDD VSS VSS gf180mcu_fd_sc_mcu7t5v0__fillcap_32
XFILLER_55_45 VDD VDD VSS VSS gf180mcu_fd_sc_mcu7t5v0__fillcap_16
XFILLER_111_40 VDD VDD VSS VSS gf180mcu_fd_sc_mcu7t5v0__fillcap_16
XTAP_TAPCELL_ROW_43_849 VDD VSS gf180mcu_fd_sc_mcu7t5v0__filltie
XTAP_TAPCELL_ROW_23_584 VDD VSS gf180mcu_fd_sc_mcu7t5v0__filltie
XFILLER_126_469 VDD VDD VSS VSS gf180mcu_fd_sc_mcu7t5v0__fill_2
XFILLER_107_694 VDD VDD VSS VSS gf180mcu_fd_sc_mcu7t5v0__fillcap_4
XFILLER_106_171 VDD VDD VSS VSS gf180mcu_fd_sc_mcu7t5v0__fillcap_4
XFILLER_122_664 VDD VDD VSS VSS gf180mcu_fd_sc_mcu7t5v0__fill_1
XFILLER_110_815 VDD VDD VSS VSS gf180mcu_fd_sc_mcu7t5v0__fillcap_4
XFILLER_67_206 VDD VDD VSS VSS gf180mcu_fd_sc_mcu7t5v0__fillcap_4
XFILLER_49_932 VDD VDD VSS VSS gf180mcu_fd_sc_mcu7t5v0__fill_2
XFILLER_67_228 VDD VDD VSS VSS gf180mcu_fd_sc_mcu7t5v0__fillcap_8
XFILLER_48_431 VDD VDD VSS VSS gf180mcu_fd_sc_mcu7t5v0__fillcap_16
XFILLER_82_209 VDD VDD VSS VSS gf180mcu_fd_sc_mcu7t5v0__fillcap_16
XFILLER_35_136 VDD VDD VSS VSS gf180mcu_fd_sc_mcu7t5v0__fillcap_4
XFILLER_48_497 VDD VDD VSS VSS gf180mcu_fd_sc_mcu7t5v0__fill_2
X_3950_ _3950_/D _2279_/I _3978_/CLK _3950_/Q VDD VDD VSS VSS gf180mcu_fd_sc_mcu7t5v0__dffrnq_1
XFILLER_91_787 VDD VDD VSS VSS gf180mcu_fd_sc_mcu7t5v0__fillcap_4
XFILLER_51_629 VDD VDD VSS VSS gf180mcu_fd_sc_mcu7t5v0__fill_1
XTAP_TAPCELL_ROW_102_1616 VDD VSS gf180mcu_fd_sc_mcu7t5v0__filltie
X_3881_ _3881_/D _4115_/CLK _3881_/Q VDD VDD VSS VSS gf180mcu_fd_sc_mcu7t5v0__dffq_1
XFILLER_77_2 VDD VDD VSS VSS gf180mcu_fd_sc_mcu7t5v0__fillcap_8
XTAP_TAPCELL_ROW_61_1081 VDD VSS gf180mcu_fd_sc_mcu7t5v0__filltie
XFILLER_6_61 VDD VDD VSS VSS gf180mcu_fd_sc_mcu7t5v0__fillcap_4
XTAP_TAPCELL_ROW_113_1756 VDD VSS gf180mcu_fd_sc_mcu7t5v0__filltie
X_3315_ _4084_/Q _3371_/A2 _3322_/A1 VDD VDD VSS VSS gf180mcu_fd_sc_mcu7t5v0__nor2_1
X_3246_ _3246_/A1 _3246_/A2 _3247_/A2 VDD VDD VSS VSS gf180mcu_fd_sc_mcu7t5v0__nor2_1
X_3177_ _4028_/Q _3996_/Q _4129_/D _4028_/D VDD VDD VSS VSS gf180mcu_fd_sc_mcu7t5v0__mux2_2
X_2128_ _3654_/Q _3662_/Q _3670_/Q _3678_/Q place79/Z place78/Z _2128_/Z VDD VDD VSS
+ VSS gf180mcu_fd_sc_mcu7t5v0__mux4_1
XFILLER_27_648 VDD VDD VSS VSS gf180mcu_fd_sc_mcu7t5v0__fillcap_8
X_2059_ _2013_/Z _2058_/Z _2061_/A2 VDD VDD VSS VSS gf180mcu_fd_sc_mcu7t5v0__nor2_1
XFILLER_82_798 VDD VDD VSS VSS gf180mcu_fd_sc_mcu7t5v0__fillcap_4
XFILLER_82_765 VDD VDD VSS VSS gf180mcu_fd_sc_mcu7t5v0__fill_1
XFILLER_25_26 VDD VDD VSS VSS gf180mcu_fd_sc_mcu7t5v0__fillcap_4
XTAP_TAPCELL_ROW_124_1896 VDD VSS gf180mcu_fd_sc_mcu7t5v0__filltie
XTAP_TAPCELL_ROW_40_808 VDD VSS gf180mcu_fd_sc_mcu7t5v0__filltie
XTAP_TAPCELL_ROW_20_543 VDD VSS gf180mcu_fd_sc_mcu7t5v0__filltie
XFILLER_104_664 VDD VDD VSS VSS gf180mcu_fd_sc_mcu7t5v0__fill_1
XFILLER_103_130 VDD VDD VSS VSS gf180mcu_fd_sc_mcu7t5v0__fillcap_8
XFILLER_131_483 VDD VDD VSS VSS gf180mcu_fd_sc_mcu7t5v0__fillcap_4
XFILLER_103_174 VDD VDD VSS VSS gf180mcu_fd_sc_mcu7t5v0__fillcap_16
XFILLER_1_279 VDD VDD VSS VSS gf180mcu_fd_sc_mcu7t5v0__fill_1
XFILLER_49_206 VDD VDD VSS VSS gf180mcu_fd_sc_mcu7t5v0__fillcap_4
XTAP_TAPCELL_ROW_48_908 VDD VSS gf180mcu_fd_sc_mcu7t5v0__filltie
XFILLER_73_743 VDD VDD VSS VSS gf180mcu_fd_sc_mcu7t5v0__fillcap_16
XTAP_TAPCELL_ROW_28_654 VDD VSS gf180mcu_fd_sc_mcu7t5v0__filltie
XFILLER_61_927 VDD VDD VSS VSS gf180mcu_fd_sc_mcu7t5v0__fillcap_4
XTAP_TAPCELL_ROW_0_290 VDD VSS gf180mcu_fd_sc_mcu7t5v0__filltie
XFILLER_9_346 VDD VDD VSS VSS gf180mcu_fd_sc_mcu7t5v0__fillcap_4
XFILLER_40_172 VDD VDD VSS VSS gf180mcu_fd_sc_mcu7t5v0__fill_2
XFILLER_127_767 VDD VDD VSS VSS gf180mcu_fd_sc_mcu7t5v0__fill_2
XFILLER_126_244 VDD VDD VSS VSS gf180mcu_fd_sc_mcu7t5v0__fill_1
XFILLER_115_907 VDD VDD VSS VSS gf180mcu_fd_sc_mcu7t5v0__fill_2
XFILLER_31_80 VDD VDD VSS VSS gf180mcu_fd_sc_mcu7t5v0__fillcap_4
XFILLER_99_139 VDD VDD VSS VSS gf180mcu_fd_sc_mcu7t5v0__fill_1
XTAP_TAPCELL_ROW_8_390 VDD VSS gf180mcu_fd_sc_mcu7t5v0__filltie
X_3100_ _3991_/Q _3100_/I1 _3160_/S _3991_/D VDD VDD VSS VSS gf180mcu_fd_sc_mcu7t5v0__mux2_2
X_4080_ _4080_/D _4157_/RN _4109_/CLK _4080_/Q VDD VDD VSS VSS gf180mcu_fd_sc_mcu7t5v0__dffrnq_1
XFILLER_68_559 VDD VDD VSS VSS gf180mcu_fd_sc_mcu7t5v0__fillcap_8
X_3031_ _3959_/Q _4047_/Q _3041_/S _3959_/D VDD VDD VSS VSS gf180mcu_fd_sc_mcu7t5v0__mux2_2
XFILLER_36_445 VDD VDD VSS VSS gf180mcu_fd_sc_mcu7t5v0__fillcap_8
XTAP_TAPCELL_ROW_63_1110 VDD VSS gf180mcu_fd_sc_mcu7t5v0__filltie
X_3933_ _3933_/D _4157_/RN _4115_/CLK _3933_/Q VDD VDD VSS VSS gf180mcu_fd_sc_mcu7t5v0__dffrnq_1
X_3864_ _3864_/D _3864_/CLK _3864_/Q VDD VDD VSS VSS gf180mcu_fd_sc_mcu7t5v0__dffq_1
XFILLER_118_701 VDD VDD VSS VSS gf180mcu_fd_sc_mcu7t5v0__fillcap_32
X_3795_ _3795_/D clkload7/I _3795_/Q VDD VDD VSS VSS gf180mcu_fd_sc_mcu7t5v0__dffq_1
X_2746_ _3828_/Q place83/Z _2746_/S _3828_/D VDD VDD VSS VSS gf180mcu_fd_sc_mcu7t5v0__mux2_2
XFILLER_105_406 VDD VDD VSS VSS gf180mcu_fd_sc_mcu7t5v0__fillcap_8
XTAP_TAPCELL_ROW_74_1250 VDD VSS gf180mcu_fd_sc_mcu7t5v0__filltie
XFILLER_113_483 VDD VDD VSS VSS gf180mcu_fd_sc_mcu7t5v0__fillcap_4
XFILLER_86_301 VDD VDD VSS VSS gf180mcu_fd_sc_mcu7t5v0__fillcap_8
XFILLER_59_559 VDD VDD VSS VSS gf180mcu_fd_sc_mcu7t5v0__fill_1
XFILLER_100_177 VDD VDD VSS VSS gf180mcu_fd_sc_mcu7t5v0__fill_2
XFILLER_86_378 VDD VDD VSS VSS gf180mcu_fd_sc_mcu7t5v0__fillcap_4
X_3229_ _4053_/Q _3983_/Q _4129_/D _4053_/D VDD VDD VSS VSS gf180mcu_fd_sc_mcu7t5v0__mux2_2
XTAP_TAPCELL_ROW_126_1925 VDD VSS gf180mcu_fd_sc_mcu7t5v0__filltie
XFILLER_95_890 VDD VDD VSS VSS gf180mcu_fd_sc_mcu7t5v0__fillcap_16
XFILLER_36_47 VDD VDD VSS VSS gf180mcu_fd_sc_mcu7t5v0__fill_1
XTAP_TAPCELL_ROW_25_613 VDD VSS gf180mcu_fd_sc_mcu7t5v0__filltie
XFILLER_27_489 VDD VDD VSS VSS gf180mcu_fd_sc_mcu7t5v0__fill_1
XTAP_TAPCELL_ROW_85_1390 VDD VSS gf180mcu_fd_sc_mcu7t5v0__filltie
XFILLER_11_824 VDD VDD VSS VSS gf180mcu_fd_sc_mcu7t5v0__fill_1
XTAP_TAPCELL_ROW_53_977 VDD VSS gf180mcu_fd_sc_mcu7t5v0__filltie
XFILLER_11_857 VDD VDD VSS VSS gf180mcu_fd_sc_mcu7t5v0__fillcap_32
XFILLER_124_737 VDD VDD VSS VSS gf180mcu_fd_sc_mcu7t5v0__fillcap_32
XFILLER_123_236 VDD VDD VSS VSS gf180mcu_fd_sc_mcu7t5v0__fill_2
XFILLER_117_72 VDD VDD VSS VSS gf180mcu_fd_sc_mcu7t5v0__fillcap_32
XFILLER_96_109 VDD VDD VSS VSS gf180mcu_fd_sc_mcu7t5v0__fill_1
XFILLER_89_150 VDD VDD VSS VSS gf180mcu_fd_sc_mcu7t5v0__fill_2
XFILLER_37_209 VDD VDD VSS VSS gf180mcu_fd_sc_mcu7t5v0__fill_1
XFILLER_45_220 VDD VDD VSS VSS gf180mcu_fd_sc_mcu7t5v0__fillcap_4
XFILLER_73_562 VDD VDD VSS VSS gf180mcu_fd_sc_mcu7t5v0__fillcap_16
XFILLER_61_702 VDD VDD VSS VSS gf180mcu_fd_sc_mcu7t5v0__fillcap_16
XFILLER_45_275 VDD VDD VSS VSS gf180mcu_fd_sc_mcu7t5v0__fillcap_4
XFILLER_41_492 VDD VDD VSS VSS gf180mcu_fd_sc_mcu7t5v0__fillcap_8
X_2600_ _4157_/RN _4123_/Q _2578_/Z _2642_/A2 VDD VDD VSS VSS gf180mcu_fd_sc_mcu7t5v0__nand3_2
XFILLER_127_553 VDD VDD VSS VSS gf180mcu_fd_sc_mcu7t5v0__fillcap_4
XFILLER_114_247 VDD VDD VSS VSS gf180mcu_fd_sc_mcu7t5v0__fillcap_16
XTAP_TAPCELL_ROW_110_1715 VDD VSS gf180mcu_fd_sc_mcu7t5v0__filltie
XFILLER_102_409 VDD VDD VSS VSS gf180mcu_fd_sc_mcu7t5v0__fillcap_8
X_2462_ place80/Z _3706_/Q _2466_/S _3706_/D VDD VDD VSS VSS gf180mcu_fd_sc_mcu7t5v0__mux2_2
XFILLER_111_932 VDD VDD VSS VSS gf180mcu_fd_sc_mcu7t5v0__fill_2
X_2393_ _3675_/Q _4073_/Q _2395_/S _3675_/D VDD VDD VSS VSS gf180mcu_fd_sc_mcu7t5v0__mux2_2
X_4132_ _4132_/D _4148_/RN _4136_/CLK _4132_/Q VDD VDD VSS VSS gf180mcu_fd_sc_mcu7t5v0__dffrnq_1
XFILLER_69_857 VDD VDD VSS VSS gf180mcu_fd_sc_mcu7t5v0__fillcap_8
XFILLER_95_142 VDD VDD VSS VSS gf180mcu_fd_sc_mcu7t5v0__fillcap_4
XTAP_TAPCELL_ROW_3_319 VDD VSS gf180mcu_fd_sc_mcu7t5v0__filltie
X_4063_ _4063_/D input92/Z _4163_/CLK _4063_/Q VDD VDD VSS VSS gf180mcu_fd_sc_mcu7t5v0__dffrnq_1
X_3014_ _3951_/Q _4039_/Q _3041_/S _3951_/D VDD VDD VSS VSS gf180mcu_fd_sc_mcu7t5v0__mux2_2
XFILLER_110_497 VDD VDD VSS VSS gf180mcu_fd_sc_mcu7t5v0__fill_1
XFILLER_95_197 VDD VDD VSS VSS gf180mcu_fd_sc_mcu7t5v0__fillcap_8
XFILLER_83_348 VDD VDD VSS VSS gf180mcu_fd_sc_mcu7t5v0__fill_2
XFILLER_92_871 VDD VDD VSS VSS gf180mcu_fd_sc_mcu7t5v0__fillcap_4
XFILLER_37_765 VDD VDD VSS VSS gf180mcu_fd_sc_mcu7t5v0__fillcap_4
XTAP_TAPCELL_ROW_108_1688 VDD VSS gf180mcu_fd_sc_mcu7t5v0__filltie
XFILLER_37_798 VDD VDD VSS VSS gf180mcu_fd_sc_mcu7t5v0__fillcap_8
XFILLER_51_212 VDD VDD VSS VSS gf180mcu_fd_sc_mcu7t5v0__fillcap_64
X_3916_ _3916_/D _4157_/RN _3975_/CLK _3916_/Q VDD VDD VSS VSS gf180mcu_fd_sc_mcu7t5v0__dffrnq_1
XTAP_TAPCELL_ROW_121_1855 VDD VSS gf180mcu_fd_sc_mcu7t5v0__filltie
XFILLER_20_621 VDD VDD VSS VSS gf180mcu_fd_sc_mcu7t5v0__fillcap_4
XTAP_TAPCELL_ROW_50_936 VDD VSS gf180mcu_fd_sc_mcu7t5v0__filltie
X_3847_ _3847_/D _3865_/CLK _3847_/Q VDD VDD VSS VSS gf180mcu_fd_sc_mcu7t5v0__dffq_1
XTAP_TAPCELL_ROW_30_671 VDD VSS gf180mcu_fd_sc_mcu7t5v0__filltie
XTAP_TAPCELL_ROW_30_682 VDD VSS gf180mcu_fd_sc_mcu7t5v0__filltie
X_3778_ _3778_/D _3877_/CLK _3778_/Q VDD VDD VSS VSS gf180mcu_fd_sc_mcu7t5v0__dffq_1
XFILLER_118_597 VDD VDD VSS VSS gf180mcu_fd_sc_mcu7t5v0__fillcap_4
XFILLER_106_737 VDD VDD VSS VSS gf180mcu_fd_sc_mcu7t5v0__fillcap_16
XFILLER_102_932 VDD VDD VSS VSS gf180mcu_fd_sc_mcu7t5v0__fill_2
XFILLER_113_291 VDD VDD VSS VSS gf180mcu_fd_sc_mcu7t5v0__fillcap_4
XFILLER_99_492 VDD VDD VSS VSS gf180mcu_fd_sc_mcu7t5v0__fillcap_64
XFILLER_59_345 VDD VDD VSS VSS gf180mcu_fd_sc_mcu7t5v0__fillcap_4
XFILLER_75_816 VDD VDD VSS VSS gf180mcu_fd_sc_mcu7t5v0__fillcap_16
XFILLER_101_486 VDD VDD VSS VSS gf180mcu_fd_sc_mcu7t5v0__fillcap_4
XPHY_EDGE_ROW_29_Right_29 VDD VSS gf180mcu_fd_sc_mcu7t5v0__endcap
XFILLER_43_702 VDD VDD VSS VSS gf180mcu_fd_sc_mcu7t5v0__fillcap_16
XFILLER_55_562 VDD VDD VSS VSS gf180mcu_fd_sc_mcu7t5v0__fillcap_4
XTAP_TAPCELL_ROW_38_782 VDD VSS gf180mcu_fd_sc_mcu7t5v0__filltie
XFILLER_42_201 VDD VDD VSS VSS gf180mcu_fd_sc_mcu7t5v0__fillcap_4
XFILLER_55_573 VDD VDD VSS VSS gf180mcu_fd_sc_mcu7t5v0__fillcap_4
XFILLER_103_96 VDD VDD VSS VSS gf180mcu_fd_sc_mcu7t5v0__fill_2
XFILLER_11_610 VDD VDD VSS VSS gf180mcu_fd_sc_mcu7t5v0__fillcap_4
XFILLER_23_492 VDD VDD VSS VSS gf180mcu_fd_sc_mcu7t5v0__fillcap_64
XFILLER_10_131 VDD VDD VSS VSS gf180mcu_fd_sc_mcu7t5v0__fillcap_4
XPHY_EDGE_ROW_38_Right_38 VDD VSS gf180mcu_fd_sc_mcu7t5v0__endcap
XFILLER_11_698 VDD VDD VSS VSS gf180mcu_fd_sc_mcu7t5v0__fill_2
XFILLER_10_164 VDD VDD VSS VSS gf180mcu_fd_sc_mcu7t5v0__fillcap_8
XFILLER_88_53 VDD VDD VSS VSS gf180mcu_fd_sc_mcu7t5v0__fillcap_32
XFILLER_3_842 VDD VDD VSS VSS gf180mcu_fd_sc_mcu7t5v0__fillcap_64
XFILLER_111_206 VDD VDD VSS VSS gf180mcu_fd_sc_mcu7t5v0__fillcap_4
XFILLER_97_418 VDD VDD VSS VSS gf180mcu_fd_sc_mcu7t5v0__fill_2
XFILLER_105_792 VDD VDD VSS VSS gf180mcu_fd_sc_mcu7t5v0__fill_2
XFILLER_120_784 VDD VDD VSS VSS gf180mcu_fd_sc_mcu7t5v0__fillcap_16
XFILLER_93_602 VDD VDD VSS VSS gf180mcu_fd_sc_mcu7t5v0__fill_1
XFILLER_77_142 VDD VDD VSS VSS gf180mcu_fd_sc_mcu7t5v0__fillcap_16
XPHY_EDGE_ROW_47_Right_47 VDD VSS gf180mcu_fd_sc_mcu7t5v0__endcap
XFILLER_80_329 VDD VDD VSS VSS gf180mcu_fd_sc_mcu7t5v0__fill_1
XFILLER_74_871 VDD VDD VSS VSS gf180mcu_fd_sc_mcu7t5v0__fillcap_4
XFILLER_33_212 VDD VDD VSS VSS gf180mcu_fd_sc_mcu7t5v0__fillcap_64
XTAP_TAPCELL_ROW_16_498 VDD VSS gf180mcu_fd_sc_mcu7t5v0__filltie
XPHY_EDGE_ROW_56_Right_56 VDD VSS gf180mcu_fd_sc_mcu7t5v0__endcap
X_3701_ _3701_/D _3968_/CLK _3701_/Q VDD VDD VSS VSS gf180mcu_fd_sc_mcu7t5v0__dffq_1
X_1893_ _3889_/Q _3890_/Q _1897_/A1 VDD VDD VSS VSS gf180mcu_fd_sc_mcu7t5v0__nor2_1
X_3632_ _3632_/D _3733_/CLK _3632_/Q VDD VDD VSS VSS gf180mcu_fd_sc_mcu7t5v0__dffq_1
X_3563_ _3783_/Q _3791_/Q _3799_/Q _3807_/Q place76/Z place75/Z _3563_/Z VDD VDD VSS
+ VSS gf180mcu_fd_sc_mcu7t5v0__mux4_1
XTAP_TAPCELL_ROW_58_1042 VDD VSS gf180mcu_fd_sc_mcu7t5v0__filltie
XFILLER_115_556 VDD VDD VSS VSS gf180mcu_fd_sc_mcu7t5v0__fillcap_4
XFILLER_89_908 VDD VDD VSS VSS gf180mcu_fd_sc_mcu7t5v0__fill_2
X_3494_ _4102_/Q _3435_/C _3493_/Z _3496_/B VDD VDD VSS VSS gf180mcu_fd_sc_mcu7t5v0__nand3_1
XFILLER_115_578 VDD VDD VSS VSS gf180mcu_fd_sc_mcu7t5v0__fillcap_8
XPHY_EDGE_ROW_65_Right_65 VDD VSS gf180mcu_fd_sc_mcu7t5v0__endcap
XPHY_EDGE_ROW_126_Left_259 VDD VSS gf180mcu_fd_sc_mcu7t5v0__endcap
XFILLER_111_762 VDD VDD VSS VSS gf180mcu_fd_sc_mcu7t5v0__fillcap_8
XFILLER_96_473 VDD VDD VSS VSS gf180mcu_fd_sc_mcu7t5v0__fill_2
XFILLER_96_451 VDD VDD VSS VSS gf180mcu_fd_sc_mcu7t5v0__fillcap_4
XFILLER_29_507 VDD VDD VSS VSS gf180mcu_fd_sc_mcu7t5v0__fillcap_16
X_4115_ _4115_/D _4157_/RN _4115_/CLK _4115_/Q VDD VDD VSS VSS gf180mcu_fd_sc_mcu7t5v0__dffrnq_1
XFILLER_83_112 VDD VDD VSS VSS gf180mcu_fd_sc_mcu7t5v0__fillcap_16
X_4046_ _4046_/D _4148_/RN _4136_/CLK _4046_/Q VDD VDD VSS VSS gf180mcu_fd_sc_mcu7t5v0__dffrnq_1
XFILLER_25_702 VDD VDD VSS VSS gf180mcu_fd_sc_mcu7t5v0__fillcap_64
XFILLER_37_562 VDD VDD VSS VSS gf180mcu_fd_sc_mcu7t5v0__fillcap_16
XTAP_TAPCELL_ROW_69_1182 VDD VSS gf180mcu_fd_sc_mcu7t5v0__filltie
XTAP_TAPCELL_ROW_35_741 VDD VSS gf180mcu_fd_sc_mcu7t5v0__filltie
XPHY_EDGE_ROW_74_Right_74 VDD VSS gf180mcu_fd_sc_mcu7t5v0__endcap
XFILLER_52_565 VDD VDD VSS VSS gf180mcu_fd_sc_mcu7t5v0__fillcap_8
XPHY_EDGE_ROW_83_Right_83 VDD VSS gf180mcu_fd_sc_mcu7t5v0__endcap
XFILLER_47_326 VDD VDD VSS VSS gf180mcu_fd_sc_mcu7t5v0__fill_2
XFILLER_59_197 VDD VDD VSS VSS gf180mcu_fd_sc_mcu7t5v0__fillcap_4
XFILLER_75_668 VDD VDD VSS VSS gf180mcu_fd_sc_mcu7t5v0__fill_1
XFILLER_90_649 VDD VDD VSS VSS gf180mcu_fd_sc_mcu7t5v0__fill_2
XFILLER_56_893 VDD VDD VSS VSS gf180mcu_fd_sc_mcu7t5v0__fillcap_8
XFILLER_62_329 VDD VDD VSS VSS gf180mcu_fd_sc_mcu7t5v0__fill_1
XPHY_EDGE_ROW_92_Right_92 VDD VSS gf180mcu_fd_sc_mcu7t5v0__endcap
XFILLER_74_99 VDD VDD VSS VSS gf180mcu_fd_sc_mcu7t5v0__fillcap_4
XFILLER_90_87 VDD VDD VSS VSS gf180mcu_fd_sc_mcu7t5v0__fill_2
XTAP_TAPCELL_ROW_13_457 VDD VSS gf180mcu_fd_sc_mcu7t5v0__filltie
XFILLER_7_422 VDD VDD VSS VSS gf180mcu_fd_sc_mcu7t5v0__fillcap_32
XFILLER_7_411 VDD VDD VSS VSS gf180mcu_fd_sc_mcu7t5v0__fillcap_8
XFILLER_7_400 VDD VDD VSS VSS gf180mcu_fd_sc_mcu7t5v0__fill_2
XTAP_TAPCELL_ROW_96_1529 VDD VSS gf180mcu_fd_sc_mcu7t5v0__filltie
XFILLER_98_749 VDD VDD VSS VSS gf180mcu_fd_sc_mcu7t5v0__fillcap_8
X_2230_ _2230_/A1 _2230_/A2 _2230_/ZN VDD VDD VSS VSS gf180mcu_fd_sc_mcu7t5v0__nand2_1
XFILLER_2_171 VDD VDD VSS VSS gf180mcu_fd_sc_mcu7t5v0__fillcap_4
XFILLER_78_451 VDD VDD VSS VSS gf180mcu_fd_sc_mcu7t5v0__fillcap_4
XFILLER_2_193 VDD VDD VSS VSS gf180mcu_fd_sc_mcu7t5v0__fillcap_8
XFILLER_66_613 VDD VDD VSS VSS gf180mcu_fd_sc_mcu7t5v0__fillcap_8
X_2161_ _2157_/Z _2158_/Z _2159_/Z _2160_/Z place77/Z _4094_/Q _2161_/Z VDD VDD VSS
+ VSS gf180mcu_fd_sc_mcu7t5v0__mux4_1
X_2092_ _2097_/A2 _2097_/A3 _2093_/A2 _2094_/A2 VDD VDD VSS VSS gf180mcu_fd_sc_mcu7t5v0__nand3_2
XFILLER_80_104 VDD VDD VSS VSS gf180mcu_fd_sc_mcu7t5v0__fill_1
XFILLER_0_52 VDD VDD VSS VSS gf180mcu_fd_sc_mcu7t5v0__fillcap_16
XFILLER_19_562 VDD VDD VSS VSS gf180mcu_fd_sc_mcu7t5v0__fill_1
XFILLER_34_510 VDD VDD VSS VSS gf180mcu_fd_sc_mcu7t5v0__fillcap_8
XTAP_TAPCELL_ROW_105_1647 VDD VSS gf180mcu_fd_sc_mcu7t5v0__filltie
XPHY_EDGE_ROW_100_Right_100 VDD VSS gf180mcu_fd_sc_mcu7t5v0__endcap
XTAP_TAPCELL_ROW_32_700 VDD VSS gf180mcu_fd_sc_mcu7t5v0__filltie
X_1945_ _4143_/Q _2079_/A1 VDD VDD VSS VSS gf180mcu_fd_sc_mcu7t5v0__clkinv_1
XFILLER_9_72 VDD VDD VSS VSS gf180mcu_fd_sc_mcu7t5v0__fillcap_16
XFILLER_119_136 VDD VDD VSS VSS gf180mcu_fd_sc_mcu7t5v0__fillcap_4
XFILLER_119_18 VDD VDD VSS VSS gf180mcu_fd_sc_mcu7t5v0__fill_1
XFILLER_9_94 VDD VDD VSS VSS gf180mcu_fd_sc_mcu7t5v0__fill_1
XFILLER_119_158 VDD VDD VSS VSS gf180mcu_fd_sc_mcu7t5v0__fillcap_8
X_1876_ _1892_/B _4136_/Q _1822_/Z _1878_/A2 VDD VDD VSS VSS gf180mcu_fd_sc_mcu7t5v0__nand3_1
XFILLER_128_692 VDD VDD VSS VSS gf180mcu_fd_sc_mcu7t5v0__fill_2
X_3615_ _4163_/Q _3627_/I1 _3615_/S _4163_/D VDD VDD VSS VSS gf180mcu_fd_sc_mcu7t5v0__mux2_2
X_3546_ _3837_/Q _3845_/Q _3853_/Q _3861_/Q place76/Z place75/Z _3546_/Z VDD VDD VSS
+ VSS gf180mcu_fd_sc_mcu7t5v0__mux4_1
XTAP_TAPCELL_ROW_116_1798 VDD VSS gf180mcu_fd_sc_mcu7t5v0__filltie
X_3477_ _4104_/Q _3477_/A2 _3418_/Z _3478_/B VDD VDD VSS VSS gf180mcu_fd_sc_mcu7t5v0__nand3_1
X_2428_ _3691_/Q _4073_/Q _2430_/S _3691_/D VDD VDD VSS VSS gf180mcu_fd_sc_mcu7t5v0__mux2_2
X_2359_ _4095_/Q _3407_/A2 _3409_/A2 VDD VDD VSS VSS gf180mcu_fd_sc_mcu7t5v0__nand2_1
XFILLER_85_933 VDD VDD VSS VSS gf180mcu_fd_sc_mcu7t5v0__fill_1
XFILLER_28_37 VDD VDD VSS VSS gf180mcu_fd_sc_mcu7t5v0__fillcap_4
XFILLER_56_101 VDD VDD VSS VSS gf180mcu_fd_sc_mcu7t5v0__fillcap_4
X_4029_ _4029_/D _4148_/RN _4138_/CLK _4029_/Q VDD VDD VSS VSS gf180mcu_fd_sc_mcu7t5v0__dffrnq_1
XFILLER_37_392 VDD VDD VSS VSS gf180mcu_fd_sc_mcu7t5v0__fill_1
XFILLER_71_137 VDD VDD VSS VSS gf180mcu_fd_sc_mcu7t5v0__fill_2
XFILLER_12_215 VDD VDD VSS VSS gf180mcu_fd_sc_mcu7t5v0__fill_1
XFILLER_100_53 VDD VDD VSS VSS gf180mcu_fd_sc_mcu7t5v0__fillcap_8
XTAP_TAPCELL_ROW_10_416 VDD VSS gf180mcu_fd_sc_mcu7t5v0__filltie
XFILLER_125_106 VDD VDD VSS VSS gf180mcu_fd_sc_mcu7t5v0__fillcap_8
XFILLER_125_139 VDD VDD VSS VSS gf180mcu_fd_sc_mcu7t5v0__fill_1
XFILLER_106_331 VDD VDD VSS VSS gf180mcu_fd_sc_mcu7t5v0__fill_1
XFILLER_107_876 VDD VDD VSS VSS gf180mcu_fd_sc_mcu7t5v0__fillcap_32
XFILLER_130_890 VDD VDD VSS VSS gf180mcu_fd_sc_mcu7t5v0__fill_2
XFILLER_102_581 VDD VDD VSS VSS gf180mcu_fd_sc_mcu7t5v0__fill_1
XFILLER_76_933 VDD VDD VSS VSS gf180mcu_fd_sc_mcu7t5v0__fill_1
XFILLER_0_675 VDD VDD VSS VSS gf180mcu_fd_sc_mcu7t5v0__fillcap_4
XFILLER_102_592 VDD VDD VSS VSS gf180mcu_fd_sc_mcu7t5v0__fill_2
XFILLER_85_65 VDD VDD VSS VSS gf180mcu_fd_sc_mcu7t5v0__fillcap_4
XTAP_TAPCELL_ROW_18_516 VDD VSS gf180mcu_fd_sc_mcu7t5v0__filltie
XFILLER_90_457 VDD VDD VSS VSS gf180mcu_fd_sc_mcu7t5v0__fillcap_8
XFILLER_16_521 VDD VDD VSS VSS gf180mcu_fd_sc_mcu7t5v0__fillcap_4
XFILLER_44_874 VDD VDD VSS VSS gf180mcu_fd_sc_mcu7t5v0__fill_1
XFILLER_93_8 VDD VDD VSS VSS gf180mcu_fd_sc_mcu7t5v0__fill_1
XFILLER_31_524 VDD VDD VSS VSS gf180mcu_fd_sc_mcu7t5v0__fillcap_16
XFILLER_8_731 VDD VDD VSS VSS gf180mcu_fd_sc_mcu7t5v0__fillcap_4
XTAP_TAPCELL_ROW_100_1588 VDD VSS gf180mcu_fd_sc_mcu7t5v0__filltie
Xhold208 s_axi_wdata[7] hold208/Z VDD VDD VSS VSS gf180mcu_fd_sc_mcu7t5v0__dlyc_1
XFILLER_109_191 VDD VDD VSS VSS gf180mcu_fd_sc_mcu7t5v0__fillcap_4
Xhold219 s_axi_wdata[10] hold219/Z VDD VDD VSS VSS gf180mcu_fd_sc_mcu7t5v0__dlyc_1
XFILLER_98_524 VDD VDD VSS VSS gf180mcu_fd_sc_mcu7t5v0__fill_1
X_3331_ _4158_/Q _3370_/A1 _3316_/Z _3337_/A1 VDD VDD VSS VSS gf180mcu_fd_sc_mcu7t5v0__nor3_1
XTAP_TAPCELL_ROW_55_1001 VDD VSS gf180mcu_fd_sc_mcu7t5v0__filltie
X_3262_ _3626_/A2 _3260_/Z _3261_/Z _3263_/A2 VDD VDD VSS VSS gf180mcu_fd_sc_mcu7t5v0__nor3_1
XFILLER_121_890 VDD VDD VSS VSS gf180mcu_fd_sc_mcu7t5v0__fillcap_4
XFILLER_22_2 VDD VDD VSS VSS gf180mcu_fd_sc_mcu7t5v0__fillcap_4
X_2213_ _2209_/Z _2210_/Z _2211_/Z _2212_/Z place77/Z _4094_/Q _2213_/Z VDD VDD VSS
+ VSS gf180mcu_fd_sc_mcu7t5v0__mux4_1
X_2144_ _3711_/Q _3719_/Q _3727_/Q _3735_/Q place79/Z place78/Z _2144_/Z VDD VDD VSS
+ VSS gf180mcu_fd_sc_mcu7t5v0__mux4_1
XFILLER_94_796 VDD VDD VSS VSS gf180mcu_fd_sc_mcu7t5v0__fillcap_8
XFILLER_93_273 VDD VDD VSS VSS gf180mcu_fd_sc_mcu7t5v0__fill_2
XFILLER_66_465 VDD VDD VSS VSS gf180mcu_fd_sc_mcu7t5v0__fill_1
X_2075_ place71/Z _2097_/A2 _2097_/A3 _2074_/Z _2077_/A2 VDD VDD VSS VSS gf180mcu_fd_sc_mcu7t5v0__nand4_1
XFILLER_34_351 VDD VDD VSS VSS gf180mcu_fd_sc_mcu7t5v0__fillcap_32
XTAP_TAPCELL_ROW_66_1141 VDD VSS gf180mcu_fd_sc_mcu7t5v0__filltie
XFILLER_50_833 VDD VDD VSS VSS gf180mcu_fd_sc_mcu7t5v0__fill_1
XFILLER_50_866 VDD VDD VSS VSS gf180mcu_fd_sc_mcu7t5v0__fillcap_8
XFILLER_50_877 VDD VDD VSS VSS gf180mcu_fd_sc_mcu7t5v0__fillcap_32
X_2977_ _3933_/Q place90/Z _3041_/S _3933_/D VDD VDD VSS VSS gf180mcu_fd_sc_mcu7t5v0__mux2_2
XTAP_TAPCELL_ROW_118_1816 VDD VSS gf180mcu_fd_sc_mcu7t5v0__filltie
X_1928_ _1923_/B _1905_/Z _1820_/Z _1822_/Z _1947_/A2 VDD VDD VSS VSS gf180mcu_fd_sc_mcu7t5v0__nor4_4
XFILLER_107_117 VDD VDD VSS VSS gf180mcu_fd_sc_mcu7t5v0__fillcap_16
X_1859_ _1901_/C _1916_/B1 _1859_/B _2008_/A2 VDD VDD VSS VSS gf180mcu_fd_sc_mcu7t5v0__aoi21_1
XFILLER_107_139 VDD VDD VSS VSS gf180mcu_fd_sc_mcu7t5v0__fill_1
XTAP_TAPCELL_ROW_77_1292 VDD VSS gf180mcu_fd_sc_mcu7t5v0__filltie
XTAP_TAPCELL_ROW_77_1281 VDD VSS gf180mcu_fd_sc_mcu7t5v0__filltie
XFILLER_1_417 VDD VDD VSS VSS gf180mcu_fd_sc_mcu7t5v0__fill_2
XFILLER_131_632 VDD VDD VSS VSS gf180mcu_fd_sc_mcu7t5v0__fill_2
X_3529_ place74/Z _3529_/A2 _4118_/D VDD VDD VSS VSS gf180mcu_fd_sc_mcu7t5v0__xnor2_1
XFILLER_39_36 VDD VDD VSS VSS gf180mcu_fd_sc_mcu7t5v0__fillcap_8
XFILLER_131_687 VDD VDD VSS VSS gf180mcu_fd_sc_mcu7t5v0__fillcap_8
XFILLER_39_69 VDD VDD VSS VSS gf180mcu_fd_sc_mcu7t5v0__fill_1
XFILLER_58_933 VDD VDD VSS VSS gf180mcu_fd_sc_mcu7t5v0__fill_1
XFILLER_29_134 VDD VDD VSS VSS gf180mcu_fd_sc_mcu7t5v0__fillcap_4
XFILLER_57_454 VDD VDD VSS VSS gf180mcu_fd_sc_mcu7t5v0__fillcap_16
XFILLER_69_292 VDD VDD VSS VSS gf180mcu_fd_sc_mcu7t5v0__fill_1
XTAP_TAPCELL_ROW_129_1967 VDD VSS gf180mcu_fd_sc_mcu7t5v0__filltie
XFILLER_44_104 VDD VDD VSS VSS gf180mcu_fd_sc_mcu7t5v0__fill_1
XFILLER_45_627 VDD VDD VSS VSS gf180mcu_fd_sc_mcu7t5v0__fill_2
XFILLER_57_476 VDD VDD VSS VSS gf180mcu_fd_sc_mcu7t5v0__fill_1
XFILLER_72_457 VDD VDD VSS VSS gf180mcu_fd_sc_mcu7t5v0__fillcap_64
XTAP_TAPCELL_ROW_43_839 VDD VSS gf180mcu_fd_sc_mcu7t5v0__filltie
XFILLER_40_343 VDD VDD VSS VSS gf180mcu_fd_sc_mcu7t5v0__fill_1
XFILLER_71_34 VDD VDD VSS VSS gf180mcu_fd_sc_mcu7t5v0__fillcap_8
XFILLER_40_387 VDD VDD VSS VSS gf180mcu_fd_sc_mcu7t5v0__fillcap_64
XFILLER_71_78 VDD VDD VSS VSS gf180mcu_fd_sc_mcu7t5v0__fill_1
XTAP_TAPCELL_ROW_23_585 VDD VSS gf180mcu_fd_sc_mcu7t5v0__filltie
XFILLER_5_745 VDD VDD VSS VSS gf180mcu_fd_sc_mcu7t5v0__fillcap_16
XFILLER_4_244 VDD VDD VSS VSS gf180mcu_fd_sc_mcu7t5v0__fill_1
XFILLER_107_684 VDD VDD VSS VSS gf180mcu_fd_sc_mcu7t5v0__fill_2
XFILLER_121_142 VDD VDD VSS VSS gf180mcu_fd_sc_mcu7t5v0__fillcap_64
XFILLER_68_719 VDD VDD VSS VSS gf180mcu_fd_sc_mcu7t5v0__fill_1
XFILLER_63_446 VDD VDD VSS VSS gf180mcu_fd_sc_mcu7t5v0__fillcap_4
XFILLER_91_766 VDD VDD VSS VSS gf180mcu_fd_sc_mcu7t5v0__fillcap_4
XFILLER_51_619 VDD VDD VSS VSS gf180mcu_fd_sc_mcu7t5v0__fillcap_8
X_2900_ _3898_/Q _4034_/Q _2900_/S _3898_/D VDD VDD VSS VSS gf180mcu_fd_sc_mcu7t5v0__mux2_2
XTAP_TAPCELL_ROW_102_1617 VDD VSS gf180mcu_fd_sc_mcu7t5v0__filltie
XTAP_TAPCELL_ROW_102_1606 VDD VSS gf180mcu_fd_sc_mcu7t5v0__filltie
XFILLER_17_896 VDD VDD VSS VSS gf180mcu_fd_sc_mcu7t5v0__fillcap_8
XFILLER_31_310 VDD VDD VSS VSS gf180mcu_fd_sc_mcu7t5v0__fill_2
XFILLER_50_107 VDD VDD VSS VSS gf180mcu_fd_sc_mcu7t5v0__fillcap_64
XFILLER_32_877 VDD VDD VSS VSS gf180mcu_fd_sc_mcu7t5v0__fill_1
X_3880_ _3880_/D _4123_/CLK _3880_/Q VDD VDD VSS VSS gf180mcu_fd_sc_mcu7t5v0__dffq_1
X_2831_ place84/Z _3867_/Q _2833_/S _3867_/D VDD VDD VSS VSS gf180mcu_fd_sc_mcu7t5v0__mux2_2
X_2762_ _3835_/Q place84/Z _2764_/S _3835_/D VDD VDD VSS VSS gf180mcu_fd_sc_mcu7t5v0__mux2_2
XTAP_TAPCELL_ROW_61_1082 VDD VSS gf180mcu_fd_sc_mcu7t5v0__filltie
XFILLER_8_594 VDD VDD VSS VSS gf180mcu_fd_sc_mcu7t5v0__fill_1
X_2693_ place83/Z _3804_/Q _2693_/S _3804_/D VDD VDD VSS VSS gf180mcu_fd_sc_mcu7t5v0__mux2_2
XFILLER_125_492 VDD VDD VSS VSS gf180mcu_fd_sc_mcu7t5v0__fillcap_32
XFILLER_125_470 VDD VDD VSS VSS gf180mcu_fd_sc_mcu7t5v0__fillcap_4
XTAP_TAPCELL_ROW_113_1757 VDD VSS gf180mcu_fd_sc_mcu7t5v0__filltie
XFILLER_113_632 VDD VDD VSS VSS gf180mcu_fd_sc_mcu7t5v0__fillcap_64
XFILLER_99_866 VDD VDD VSS VSS gf180mcu_fd_sc_mcu7t5v0__fill_2
X_3314_ _4082_/Q _4081_/Q _4083_/Q _3371_/A2 VDD VDD VSS VSS gf180mcu_fd_sc_mcu7t5v0__nand3_1
X_3245_ _4060_/Q _3246_/A1 VDD VDD VSS VSS gf180mcu_fd_sc_mcu7t5v0__clkinv_1
XFILLER_101_838 VDD VDD VSS VSS gf180mcu_fd_sc_mcu7t5v0__fill_2
XFILLER_98_387 VDD VDD VSS VSS gf180mcu_fd_sc_mcu7t5v0__fill_2
XFILLER_86_549 VDD VDD VSS VSS gf180mcu_fd_sc_mcu7t5v0__fill_1
XFILLER_86_527 VDD VDD VSS VSS gf180mcu_fd_sc_mcu7t5v0__fillcap_16
XFILLER_58_229 VDD VDD VSS VSS gf180mcu_fd_sc_mcu7t5v0__fillcap_16
XFILLER_82_711 VDD VDD VSS VSS gf180mcu_fd_sc_mcu7t5v0__fillcap_16
XFILLER_39_487 VDD VDD VSS VSS gf180mcu_fd_sc_mcu7t5v0__fill_2
XFILLER_66_262 VDD VDD VSS VSS gf180mcu_fd_sc_mcu7t5v0__fill_1
X_2127_ _3742_/Q _3750_/Q _3638_/Q _3646_/Q place79/Z place78/Z _2127_/Z VDD VDD VSS
+ VSS gf180mcu_fd_sc_mcu7t5v0__mux4_1
XFILLER_66_295 VDD VDD VSS VSS gf180mcu_fd_sc_mcu7t5v0__fillcap_16
X_2058_ _2058_/A1 _2063_/A2 _2058_/Z VDD VDD VSS VSS gf180mcu_fd_sc_mcu7t5v0__xor2_1
XFILLER_54_457 VDD VDD VSS VSS gf180mcu_fd_sc_mcu7t5v0__fillcap_4
XFILLER_81_276 VDD VDD VSS VSS gf180mcu_fd_sc_mcu7t5v0__fillcap_4
XFILLER_41_118 VDD VDD VSS VSS gf180mcu_fd_sc_mcu7t5v0__fillcap_16
XTAP_TAPCELL_ROW_124_1897 VDD VSS gf180mcu_fd_sc_mcu7t5v0__filltie
XTAP_TAPCELL_ROW_40_809 VDD VSS gf180mcu_fd_sc_mcu7t5v0__filltie
XTAP_TAPCELL_ROW_79_1310 VDD VSS gf180mcu_fd_sc_mcu7t5v0__filltie
XFILLER_10_527 VDD VDD VSS VSS gf180mcu_fd_sc_mcu7t5v0__fillcap_16
XFILLER_22_387 VDD VDD VSS VSS gf180mcu_fd_sc_mcu7t5v0__fillcap_4
XFILLER_108_404 VDD VDD VSS VSS gf180mcu_fd_sc_mcu7t5v0__fill_1
XTAP_TAPCELL_ROW_20_544 VDD VSS gf180mcu_fd_sc_mcu7t5v0__filltie
XFILLER_123_418 VDD VDD VSS VSS gf180mcu_fd_sc_mcu7t5v0__fill_2
XFILLER_116_481 VDD VDD VSS VSS gf180mcu_fd_sc_mcu7t5v0__fill_2
XFILLER_2_737 VDD VDD VSS VSS gf180mcu_fd_sc_mcu7t5v0__fillcap_8
XFILLER_104_654 VDD VDD VSS VSS gf180mcu_fd_sc_mcu7t5v0__fillcap_8
XFILLER_103_142 VDD VDD VSS VSS gf180mcu_fd_sc_mcu7t5v0__fillcap_32
XFILLER_131_462 VDD VDD VSS VSS gf180mcu_fd_sc_mcu7t5v0__fillcap_4
XFILLER_77_516 VDD VDD VSS VSS gf180mcu_fd_sc_mcu7t5v0__fill_1
XTAP_TAPCELL_ROW_48_909 VDD VSS gf180mcu_fd_sc_mcu7t5v0__filltie
XFILLER_66_34 VDD VDD VSS VSS gf180mcu_fd_sc_mcu7t5v0__fill_1
XFILLER_46_903 VDD VDD VSS VSS gf180mcu_fd_sc_mcu7t5v0__fill_1
XFILLER_17_104 VDD VDD VSS VSS gf180mcu_fd_sc_mcu7t5v0__fillcap_16
XTAP_TAPCELL_ROW_28_644 VDD VSS gf180mcu_fd_sc_mcu7t5v0__filltie
XTAP_TAPCELL_ROW_28_655 VDD VSS gf180mcu_fd_sc_mcu7t5v0__filltie
XTAP_TAPCELL_ROW_0_280 VDD VSS gf180mcu_fd_sc_mcu7t5v0__filltie
Xclkbuf_leaf_52_clk clkload0/I _3835_/CLK VDD VDD VSS VSS gf180mcu_fd_sc_mcu7t5v0__clkbuf_8
XTAP_TAPCELL_ROW_0_291 VDD VSS gf180mcu_fd_sc_mcu7t5v0__filltie
XFILLER_14_877 VDD VDD VSS VSS gf180mcu_fd_sc_mcu7t5v0__fillcap_8
XFILLER_41_696 VDD VDD VSS VSS gf180mcu_fd_sc_mcu7t5v0__fillcap_4
XFILLER_127_702 VDD VDD VSS VSS gf180mcu_fd_sc_mcu7t5v0__fillcap_4
XFILLER_107_492 VDD VDD VSS VSS gf180mcu_fd_sc_mcu7t5v0__fillcap_32
XTAP_TAPCELL_ROW_8_391 VDD VSS gf180mcu_fd_sc_mcu7t5v0__filltie
XFILLER_68_527 VDD VDD VSS VSS gf180mcu_fd_sc_mcu7t5v0__fillcap_32
XFILLER_64_711 VDD VDD VSS VSS gf180mcu_fd_sc_mcu7t5v0__fillcap_16
XFILLER_76_593 VDD VDD VSS VSS gf180mcu_fd_sc_mcu7t5v0__fill_2
XFILLER_91_552 VDD VDD VSS VSS gf180mcu_fd_sc_mcu7t5v0__fillcap_8
XFILLER_36_457 VDD VDD VSS VSS gf180mcu_fd_sc_mcu7t5v0__fillcap_16
XTAP_TAPCELL_ROW_63_1100 VDD VSS gf180mcu_fd_sc_mcu7t5v0__filltie
XFILLER_63_276 VDD VDD VSS VSS gf180mcu_fd_sc_mcu7t5v0__fillcap_4
XTAP_TAPCELL_ROW_63_1111 VDD VSS gf180mcu_fd_sc_mcu7t5v0__filltie
X_3932_ _3932_/D _2279_/I _3981_/CLK _3932_/Q VDD VDD VSS VSS gf180mcu_fd_sc_mcu7t5v0__dffrnq_1
Xclkbuf_leaf_43_clk clkload4/I _4166_/CLK VDD VDD VSS VSS gf180mcu_fd_sc_mcu7t5v0__clkbuf_8
X_3863_ _3863_/D _3865_/CLK _3863_/Q VDD VDD VSS VSS gf180mcu_fd_sc_mcu7t5v0__dffq_1
X_2814_ place84/Z _3859_/Q _2816_/S _3859_/D VDD VDD VSS VSS gf180mcu_fd_sc_mcu7t5v0__mux2_2
X_3794_ _3794_/D clkload8/I _3794_/Q VDD VDD VSS VSS gf180mcu_fd_sc_mcu7t5v0__dffq_1
XFILLER_117_212 VDD VDD VSS VSS gf180mcu_fd_sc_mcu7t5v0__fillcap_64
XFILLER_127_18 VDD VDD VSS VSS gf180mcu_fd_sc_mcu7t5v0__fillcap_4
XFILLER_106_919 VDD VDD VSS VSS gf180mcu_fd_sc_mcu7t5v0__fillcap_8
XFILLER_105_418 VDD VDD VSS VSS gf180mcu_fd_sc_mcu7t5v0__fill_2
X_2676_ place83/Z _3796_/Q _2676_/S _3796_/D VDD VDD VSS VSS gf180mcu_fd_sc_mcu7t5v0__mux2_2
XTAP_TAPCELL_ROW_74_1251 VDD VSS gf180mcu_fd_sc_mcu7t5v0__filltie
XFILLER_101_602 VDD VDD VSS VSS gf180mcu_fd_sc_mcu7t5v0__fillcap_8
XFILLER_98_173 VDD VDD VSS VSS gf180mcu_fd_sc_mcu7t5v0__fill_2
XFILLER_87_836 VDD VDD VSS VSS gf180mcu_fd_sc_mcu7t5v0__fillcap_4
XFILLER_86_313 VDD VDD VSS VSS gf180mcu_fd_sc_mcu7t5v0__fill_2
XFILLER_86_346 VDD VDD VSS VSS gf180mcu_fd_sc_mcu7t5v0__fillcap_32
XFILLER_28_925 VDD VDD VSS VSS gf180mcu_fd_sc_mcu7t5v0__fillcap_8
XFILLER_39_240 VDD VDD VSS VSS gf180mcu_fd_sc_mcu7t5v0__fillcap_16
XTAP_TAPCELL_ROW_126_1926 VDD VSS gf180mcu_fd_sc_mcu7t5v0__filltie
XFILLER_36_37 VDD VDD VSS VSS gf180mcu_fd_sc_mcu7t5v0__fillcap_8
XFILLER_67_593 VDD VDD VSS VSS gf180mcu_fd_sc_mcu7t5v0__fillcap_8
XFILLER_55_766 VDD VDD VSS VSS gf180mcu_fd_sc_mcu7t5v0__fillcap_4
XFILLER_14_107 VDD VDD VSS VSS gf180mcu_fd_sc_mcu7t5v0__fillcap_64
XTAP_TAPCELL_ROW_25_614 VDD VSS gf180mcu_fd_sc_mcu7t5v0__filltie
XFILLER_43_928 VDD VDD VSS VSS gf180mcu_fd_sc_mcu7t5v0__fillcap_4
XTAP_TAPCELL_ROW_85_1391 VDD VSS gf180mcu_fd_sc_mcu7t5v0__filltie
Xclkbuf_leaf_34_clk clkload5/I _4114_/CLK VDD VDD VSS VSS gf180mcu_fd_sc_mcu7t5v0__clkbuf_8
XTAP_TAPCELL_ROW_53_978 VDD VSS gf180mcu_fd_sc_mcu7t5v0__filltie
XFILLER_109_702 VDD VDD VSS VSS gf180mcu_fd_sc_mcu7t5v0__fillcap_8
XFILLER_6_317 VDD VDD VSS VSS gf180mcu_fd_sc_mcu7t5v0__fillcap_64
XFILLER_109_746 VDD VDD VSS VSS gf180mcu_fd_sc_mcu7t5v0__fillcap_4
XFILLER_120_933 VDD VDD VSS VSS gf180mcu_fd_sc_mcu7t5v0__fill_1
XFILLER_77_44 VDD VDD VSS VSS gf180mcu_fd_sc_mcu7t5v0__fillcap_16
XFILLER_77_346 VDD VDD VSS VSS gf180mcu_fd_sc_mcu7t5v0__fillcap_4
XFILLER_92_305 VDD VDD VSS VSS gf180mcu_fd_sc_mcu7t5v0__fillcap_8
XFILLER_77_368 VDD VDD VSS VSS gf180mcu_fd_sc_mcu7t5v0__fill_2
XTAP_TAPCELL_ROW_5_350 VDD VSS gf180mcu_fd_sc_mcu7t5v0__filltie
XFILLER_46_733 VDD VDD VSS VSS gf180mcu_fd_sc_mcu7t5v0__fill_2
XFILLER_93_43 VDD VDD VSS VSS gf180mcu_fd_sc_mcu7t5v0__fillcap_8
XFILLER_18_457 VDD VDD VSS VSS gf180mcu_fd_sc_mcu7t5v0__fillcap_64
XFILLER_33_416 VDD VDD VSS VSS gf180mcu_fd_sc_mcu7t5v0__fillcap_4
XFILLER_34_928 VDD VDD VSS VSS gf180mcu_fd_sc_mcu7t5v0__fillcap_4
XFILLER_60_213 VDD VDD VSS VSS gf180mcu_fd_sc_mcu7t5v0__fill_2
Xclkbuf_leaf_25_clk clkload6/I _4125_/CLK VDD VDD VSS VSS gf180mcu_fd_sc_mcu7t5v0__clkbuf_8
XFILLER_42_80 VDD VDD VSS VSS gf180mcu_fd_sc_mcu7t5v0__fillcap_16
XFILLER_6_873 VDD VDD VSS VSS gf180mcu_fd_sc_mcu7t5v0__fill_2
X_2530_ place81/Z _3736_/Q _2538_/S _3736_/D VDD VDD VSS VSS gf180mcu_fd_sc_mcu7t5v0__mux2_2
XPHY_EDGE_ROW_39_Left_172 VDD VSS gf180mcu_fd_sc_mcu7t5v0__endcap
XTAP_TAPCELL_ROW_110_1716 VDD VSS gf180mcu_fd_sc_mcu7t5v0__filltie
XFILLER_122_270 VDD VDD VSS VSS gf180mcu_fd_sc_mcu7t5v0__fillcap_8
X_4131_ _4131_/D input92/Z clkload9/I _4131_/Q VDD VDD VSS VSS gf180mcu_fd_sc_mcu7t5v0__dffrnq_1
X_4062_ _4062_/D input92/Z _4163_/CLK _4062_/Q VDD VDD VSS VSS gf180mcu_fd_sc_mcu7t5v0__dffrnq_1
XFILLER_68_379 VDD VDD VSS VSS gf180mcu_fd_sc_mcu7t5v0__fillcap_4
XFILLER_36_243 VDD VDD VSS VSS gf180mcu_fd_sc_mcu7t5v0__fill_2
XTAP_TAPCELL_ROW_108_1689 VDD VSS gf180mcu_fd_sc_mcu7t5v0__filltie
XFILLER_92_894 VDD VDD VSS VSS gf180mcu_fd_sc_mcu7t5v0__fill_1
XFILLER_25_928 VDD VDD VSS VSS gf180mcu_fd_sc_mcu7t5v0__fillcap_4
XPHY_EDGE_ROW_48_Left_181 VDD VSS gf180mcu_fd_sc_mcu7t5v0__endcap
XFILLER_51_202 VDD VDD VSS VSS gf180mcu_fd_sc_mcu7t5v0__fillcap_8
XFILLER_64_563 VDD VDD VSS VSS gf180mcu_fd_sc_mcu7t5v0__fillcap_32
Xclkbuf_leaf_16_clk clkload1/I _4147_/CLK VDD VDD VSS VSS gf180mcu_fd_sc_mcu7t5v0__clkbuf_8
X_3915_ _3915_/D _4157_/RN _3975_/CLK _3915_/Q VDD VDD VSS VSS gf180mcu_fd_sc_mcu7t5v0__dffrnq_1
XTAP_TAPCELL_ROW_121_1856 VDD VSS gf180mcu_fd_sc_mcu7t5v0__filltie
XTAP_TAPCELL_ROW_50_937 VDD VSS gf180mcu_fd_sc_mcu7t5v0__filltie
XFILLER_60_791 VDD VDD VSS VSS gf180mcu_fd_sc_mcu7t5v0__fillcap_8
X_3846_ _3846_/D _3866_/CLK _3846_/Q VDD VDD VSS VSS gf180mcu_fd_sc_mcu7t5v0__dffq_1
XFILLER_118_521 VDD VDD VSS VSS gf180mcu_fd_sc_mcu7t5v0__fillcap_4
XFILLER_20_677 VDD VDD VSS VSS gf180mcu_fd_sc_mcu7t5v0__fill_1
XTAP_TAPCELL_ROW_30_672 VDD VSS gf180mcu_fd_sc_mcu7t5v0__filltie
X_3777_ _3777_/D _4115_/CLK _3777_/Q VDD VDD VSS VSS gf180mcu_fd_sc_mcu7t5v0__dffq_1
XFILLER_106_716 VDD VDD VSS VSS gf180mcu_fd_sc_mcu7t5v0__fillcap_16
X_2728_ _3820_/Q place83/Z _2728_/S _3820_/D VDD VDD VSS VSS gf180mcu_fd_sc_mcu7t5v0__mux2_2
XPHY_EDGE_ROW_57_Left_190 VDD VSS gf180mcu_fd_sc_mcu7t5v0__endcap
XTAP_TAPCELL_ROW_132_1996 VDD VSS gf180mcu_fd_sc_mcu7t5v0__filltie
XFILLER_59_313 VDD VDD VSS VSS gf180mcu_fd_sc_mcu7t5v0__fillcap_32
XFILLER_59_368 VDD VDD VSS VSS gf180mcu_fd_sc_mcu7t5v0__fill_2
XPHY_EDGE_ROW_114_Right_114 VDD VSS gf180mcu_fd_sc_mcu7t5v0__endcap
XTAP_TAPCELL_ROW_87_1420 VDD VSS gf180mcu_fd_sc_mcu7t5v0__filltie
XFILLER_87_699 VDD VDD VSS VSS gf180mcu_fd_sc_mcu7t5v0__fill_1
XFILLER_83_894 VDD VDD VSS VSS gf180mcu_fd_sc_mcu7t5v0__fill_1
XFILLER_15_416 VDD VDD VSS VSS gf180mcu_fd_sc_mcu7t5v0__fillcap_4
XTAP_TAPCELL_ROW_38_783 VDD VSS gf180mcu_fd_sc_mcu7t5v0__filltie
XFILLER_82_382 VDD VDD VSS VSS gf180mcu_fd_sc_mcu7t5v0__fill_2
XFILLER_27_298 VDD VDD VSS VSS gf180mcu_fd_sc_mcu7t5v0__fillcap_8
XFILLER_43_769 VDD VDD VSS VSS gf180mcu_fd_sc_mcu7t5v0__fill_1
XFILLER_30_419 VDD VDD VSS VSS gf180mcu_fd_sc_mcu7t5v0__fillcap_16
XFILLER_7_626 VDD VDD VSS VSS gf180mcu_fd_sc_mcu7t5v0__fillcap_4
XFILLER_7_648 VDD VDD VSS VSS gf180mcu_fd_sc_mcu7t5v0__fill_2
XFILLER_109_554 VDD VDD VSS VSS gf180mcu_fd_sc_mcu7t5v0__fillcap_4
XTAP_TAPCELL_ROW_98_1560 VDD VSS gf180mcu_fd_sc_mcu7t5v0__filltie
XFILLER_98_909 VDD VDD VSS VSS gf180mcu_fd_sc_mcu7t5v0__fillcap_16
XFILLER_77_121 VDD VDD VSS VSS gf180mcu_fd_sc_mcu7t5v0__fillcap_16
XFILLER_120_752 VDD VDD VSS VSS gf180mcu_fd_sc_mcu7t5v0__fillcap_32
XFILLER_19_766 VDD VDD VSS VSS gf180mcu_fd_sc_mcu7t5v0__fillcap_4
XFILLER_80_308 VDD VDD VSS VSS gf180mcu_fd_sc_mcu7t5v0__fillcap_4
XFILLER_18_287 VDD VDD VSS VSS gf180mcu_fd_sc_mcu7t5v0__fill_1
XFILLER_34_769 VDD VDD VSS VSS gf180mcu_fd_sc_mcu7t5v0__fillcap_4
XFILLER_21_419 VDD VDD VSS VSS gf180mcu_fd_sc_mcu7t5v0__fill_1
X_1961_ _3083_/A1 _3249_/A1 _4059_/Q _3249_/B VDD VDD VSS VSS gf180mcu_fd_sc_mcu7t5v0__nor3_1
XTAP_TAPCELL_ROW_16_499 VDD VSS gf180mcu_fd_sc_mcu7t5v0__filltie
XTAP_TAPCELL_ROW_16_488 VDD VSS gf180mcu_fd_sc_mcu7t5v0__filltie
X_3700_ _3700_/D _3732_/CLK _3700_/Q VDD VDD VSS VSS gf180mcu_fd_sc_mcu7t5v0__dffq_1
X_1892_ _4137_/Q _1892_/A2 _1892_/B _1892_/C _1899_/A3 VDD VDD VSS VSS gf180mcu_fd_sc_mcu7t5v0__aoi211_1
XFILLER_14_493 VDD VDD VSS VSS gf180mcu_fd_sc_mcu7t5v0__fill_2
X_3631_ _3631_/D _3729_/CLK _3631_/Q VDD VDD VSS VSS gf180mcu_fd_sc_mcu7t5v0__dffq_1
XFILLER_128_874 VDD VDD VSS VSS gf180mcu_fd_sc_mcu7t5v0__fill_1
X_3562_ _3871_/Q _3879_/Q _3767_/Q _3775_/Q place76/Z place75/Z _3562_/Z VDD VDD VSS
+ VSS gf180mcu_fd_sc_mcu7t5v0__mux4_1
XFILLER_52_2 VDD VDD VSS VSS gf180mcu_fd_sc_mcu7t5v0__fillcap_32
XTAP_TAPCELL_ROW_58_1043 VDD VSS gf180mcu_fd_sc_mcu7t5v0__filltie
X_2513_ _3728_/Q place81/Z _2521_/S _3728_/D VDD VDD VSS VSS gf180mcu_fd_sc_mcu7t5v0__mux2_2
XFILLER_5_180 VDD VDD VSS VSS gf180mcu_fd_sc_mcu7t5v0__fillcap_4
X_3493_ _3493_/A1 _3490_/Z _3492_/Z _3493_/Z VDD VDD VSS VSS gf180mcu_fd_sc_mcu7t5v0__xor3_1
XFILLER_130_527 VDD VDD VSS VSS gf180mcu_fd_sc_mcu7t5v0__fill_1
X_2444_ _3698_/Q place80/Z _2448_/S _3698_/D VDD VDD VSS VSS gf180mcu_fd_sc_mcu7t5v0__mux2_2
XFILLER_88_419 VDD VDD VSS VSS gf180mcu_fd_sc_mcu7t5v0__fillcap_16
XTAP_TAPCELL_ROW_71_1210 VDD VSS gf180mcu_fd_sc_mcu7t5v0__filltie
Xclkbuf_leaf_5_clk clkbuf_leaf_5_clk/I _4123_/CLK VDD VDD VSS VSS gf180mcu_fd_sc_mcu7t5v0__clkbuf_8
X_2375_ _3667_/Q _4073_/Q _2377_/S _3667_/D VDD VDD VSS VSS gf180mcu_fd_sc_mcu7t5v0__mux2_2
X_4114_ _4114_/D _2279_/I _4114_/CLK _4114_/Q VDD VDD VSS VSS gf180mcu_fd_sc_mcu7t5v0__dffrnq_1
XFILLER_111_796 VDD VDD VSS VSS gf180mcu_fd_sc_mcu7t5v0__fill_2
XFILLER_69_699 VDD VDD VSS VSS gf180mcu_fd_sc_mcu7t5v0__fill_1
X_4045_ _4045_/D input92/Z _4045_/CLK _4045_/Q VDD VDD VSS VSS gf180mcu_fd_sc_mcu7t5v0__dffrnq_1
XFILLER_52_500 VDD VDD VSS VSS gf180mcu_fd_sc_mcu7t5v0__fillcap_16
XFILLER_52_533 VDD VDD VSS VSS gf180mcu_fd_sc_mcu7t5v0__fillcap_32
XTAP_TAPCELL_ROW_69_1183 VDD VSS gf180mcu_fd_sc_mcu7t5v0__filltie
XTAP_TAPCELL_ROW_82_1350 VDD VSS gf180mcu_fd_sc_mcu7t5v0__filltie
XFILLER_12_419 VDD VDD VSS VSS gf180mcu_fd_sc_mcu7t5v0__fillcap_4
XTAP_TAPCELL_ROW_35_742 VDD VSS gf180mcu_fd_sc_mcu7t5v0__filltie
XFILLER_52_577 VDD VDD VSS VSS gf180mcu_fd_sc_mcu7t5v0__fill_1
XFILLER_24_279 VDD VDD VSS VSS gf180mcu_fd_sc_mcu7t5v0__fillcap_32
X_3829_ _3829_/D _4153_/CLK _3829_/Q VDD VDD VSS VSS gf180mcu_fd_sc_mcu7t5v0__dffq_1
XFILLER_106_524 VDD VDD VSS VSS gf180mcu_fd_sc_mcu7t5v0__fill_1
XFILLER_109_6 VDD VDD VSS VSS gf180mcu_fd_sc_mcu7t5v0__fill_2
XFILLER_106_535 VDD VDD VSS VSS gf180mcu_fd_sc_mcu7t5v0__fillcap_4
XFILLER_3_139 VDD VDD VSS VSS gf180mcu_fd_sc_mcu7t5v0__fill_1
XFILLER_79_408 VDD VDD VSS VSS gf180mcu_fd_sc_mcu7t5v0__fillcap_4
XTAP_TAPCELL_ROW_93_1490 VDD VSS gf180mcu_fd_sc_mcu7t5v0__filltie
XFILLER_87_430 VDD VDD VSS VSS gf180mcu_fd_sc_mcu7t5v0__fillcap_4
XFILLER_0_868 VDD VDD VSS VSS gf180mcu_fd_sc_mcu7t5v0__fillcap_16
XFILLER_58_79 VDD VDD VSS VSS gf180mcu_fd_sc_mcu7t5v0__fillcap_16
XFILLER_87_474 VDD VDD VSS VSS gf180mcu_fd_sc_mcu7t5v0__fillcap_16
XFILLER_75_625 VDD VDD VSS VSS gf180mcu_fd_sc_mcu7t5v0__fillcap_4
XFILLER_74_168 VDD VDD VSS VSS gf180mcu_fd_sc_mcu7t5v0__fillcap_4
XFILLER_15_202 VDD VDD VSS VSS gf180mcu_fd_sc_mcu7t5v0__fillcap_8
XFILLER_56_872 VDD VDD VSS VSS gf180mcu_fd_sc_mcu7t5v0__fill_2
XFILLER_43_533 VDD VDD VSS VSS gf180mcu_fd_sc_mcu7t5v0__fillcap_16
XFILLER_71_875 VDD VDD VSS VSS gf180mcu_fd_sc_mcu7t5v0__fill_2
XFILLER_16_769 VDD VDD VSS VSS gf180mcu_fd_sc_mcu7t5v0__fillcap_4
XFILLER_70_352 VDD VDD VSS VSS gf180mcu_fd_sc_mcu7t5v0__fillcap_8
XFILLER_15_279 VDD VDD VSS VSS gf180mcu_fd_sc_mcu7t5v0__fill_1
XFILLER_12_931 VDD VDD VSS VSS gf180mcu_fd_sc_mcu7t5v0__fill_2
XTAP_TAPCELL_ROW_13_458 VDD VSS gf180mcu_fd_sc_mcu7t5v0__filltie
XFILLER_11_430 VDD VDD VSS VSS gf180mcu_fd_sc_mcu7t5v0__fillcap_4
XFILLER_129_638 VDD VDD VSS VSS gf180mcu_fd_sc_mcu7t5v0__fill_1
XFILLER_128_159 VDD VDD VSS VSS gf180mcu_fd_sc_mcu7t5v0__fillcap_16
XFILLER_125_833 VDD VDD VSS VSS gf180mcu_fd_sc_mcu7t5v0__fillcap_4
XFILLER_124_310 VDD VDD VSS VSS gf180mcu_fd_sc_mcu7t5v0__fillcap_4
XFILLER_124_365 VDD VDD VSS VSS gf180mcu_fd_sc_mcu7t5v0__fillcap_8
XFILLER_124_387 VDD VDD VSS VSS gf180mcu_fd_sc_mcu7t5v0__fillcap_64
XFILLER_112_527 VDD VDD VSS VSS gf180mcu_fd_sc_mcu7t5v0__fillcap_8
XFILLER_93_422 VDD VDD VSS VSS gf180mcu_fd_sc_mcu7t5v0__fillcap_64
XFILLER_93_411 VDD VDD VSS VSS gf180mcu_fd_sc_mcu7t5v0__fillcap_8
X_2160_ _3656_/Q _3664_/Q _3672_/Q _3680_/Q place79/Z place78/Z _2160_/Z VDD VDD VSS
+ VSS gf180mcu_fd_sc_mcu7t5v0__mux4_1
XFILLER_66_636 VDD VDD VSS VSS gf180mcu_fd_sc_mcu7t5v0__fillcap_16
X_2091_ _2013_/Z _2091_/A2 _2093_/A2 VDD VDD VSS VSS gf180mcu_fd_sc_mcu7t5v0__nor2_1
XFILLER_120_593 VDD VDD VSS VSS gf180mcu_fd_sc_mcu7t5v0__fill_2
XFILLER_34_522 VDD VDD VSS VSS gf180mcu_fd_sc_mcu7t5v0__fill_2
XFILLER_46_382 VDD VDD VSS VSS gf180mcu_fd_sc_mcu7t5v0__fill_2
XTAP_TAPCELL_ROW_105_1648 VDD VSS gf180mcu_fd_sc_mcu7t5v0__filltie
XFILLER_22_717 VDD VDD VSS VSS gf180mcu_fd_sc_mcu7t5v0__fillcap_16
X_2993_ _3941_/Q _4029_/Q _3041_/S _3941_/D VDD VDD VSS VSS gf180mcu_fd_sc_mcu7t5v0__mux2_2
XTAP_TAPCELL_ROW_32_701 VDD VSS gf180mcu_fd_sc_mcu7t5v0__filltie
XFILLER_34_588 VDD VDD VSS VSS gf180mcu_fd_sc_mcu7t5v0__fillcap_4
X_1944_ _4147_/Q _1934_/Z _1944_/B _1944_/C _2097_/A2 VDD VDD VSS VSS gf180mcu_fd_sc_mcu7t5v0__aoi211_4
XFILLER_21_238 VDD VDD VSS VSS gf180mcu_fd_sc_mcu7t5v0__fillcap_4
XFILLER_30_772 VDD VDD VSS VSS gf180mcu_fd_sc_mcu7t5v0__fill_1
X_1875_ _3889_/Q _1892_/B VDD VDD VSS VSS gf180mcu_fd_sc_mcu7t5v0__clkinv_1
X_3614_ _3626_/A1 _4064_/Q _3607_/Z _3615_/S VDD VDD VSS VSS gf180mcu_fd_sc_mcu7t5v0__nor3_1
XFILLER_128_671 VDD VDD VSS VSS gf180mcu_fd_sc_mcu7t5v0__fill_2
X_3545_ _3757_/Q _3813_/Q _3821_/Q _3829_/Q _4116_/Q place75/Z _3545_/Z VDD VDD VSS
+ VSS gf180mcu_fd_sc_mcu7t5v0__mux4_1
XFILLER_116_877 VDD VDD VSS VSS gf180mcu_fd_sc_mcu7t5v0__fillcap_8
XTAP_TAPCELL_ROW_116_1799 VDD VSS gf180mcu_fd_sc_mcu7t5v0__filltie
XTAP_TAPCELL_ROW_116_1788 VDD VSS gf180mcu_fd_sc_mcu7t5v0__filltie
X_3476_ _2182_/Z _3418_/Z _3476_/B _3478_/A2 VDD VDD VSS VSS gf180mcu_fd_sc_mcu7t5v0__aoi21_1
XFILLER_131_858 VDD VDD VSS VSS gf180mcu_fd_sc_mcu7t5v0__fillcap_16
XFILLER_69_452 VDD VDD VSS VSS gf180mcu_fd_sc_mcu7t5v0__fill_1
XFILLER_97_783 VDD VDD VSS VSS gf180mcu_fd_sc_mcu7t5v0__fillcap_4
XFILLER_96_271 VDD VDD VSS VSS gf180mcu_fd_sc_mcu7t5v0__fill_2
XFILLER_45_809 VDD VDD VSS VSS gf180mcu_fd_sc_mcu7t5v0__fillcap_16
X_4028_ _4028_/D input92/Z _4028_/CLK _4028_/Q VDD VDD VSS VSS gf180mcu_fd_sc_mcu7t5v0__dffrnq_1
XFILLER_71_105 VDD VDD VSS VSS gf180mcu_fd_sc_mcu7t5v0__fillcap_32
XFILLER_53_842 VDD VDD VSS VSS gf180mcu_fd_sc_mcu7t5v0__fillcap_8
XFILLER_80_661 VDD VDD VSS VSS gf180mcu_fd_sc_mcu7t5v0__fillcap_4
XFILLER_44_37 VDD VDD VSS VSS gf180mcu_fd_sc_mcu7t5v0__fillcap_16
XFILLER_53_886 VDD VDD VSS VSS gf180mcu_fd_sc_mcu7t5v0__fillcap_4
XFILLER_21_772 VDD VDD VSS VSS gf180mcu_fd_sc_mcu7t5v0__fillcap_16
XTAP_TAPCELL_ROW_10_417 VDD VSS gf180mcu_fd_sc_mcu7t5v0__filltie
XFILLER_125_129 VDD VDD VSS VSS gf180mcu_fd_sc_mcu7t5v0__fillcap_8
XFILLER_109_52 VDD VDD VSS VSS gf180mcu_fd_sc_mcu7t5v0__fill_1
XFILLER_4_426 VDD VDD VSS VSS gf180mcu_fd_sc_mcu7t5v0__fillcap_8
XFILLER_109_96 VDD VDD VSS VSS gf180mcu_fd_sc_mcu7t5v0__fillcap_4
XFILLER_106_387 VDD VDD VSS VSS gf180mcu_fd_sc_mcu7t5v0__fillcap_64
XFILLER_79_216 VDD VDD VSS VSS gf180mcu_fd_sc_mcu7t5v0__fill_2
XFILLER_121_379 VDD VDD VSS VSS gf180mcu_fd_sc_mcu7t5v0__fillcap_32
XFILLER_76_923 VDD VDD VSS VSS gf180mcu_fd_sc_mcu7t5v0__fillcap_8
XFILLER_87_282 VDD VDD VSS VSS gf180mcu_fd_sc_mcu7t5v0__fillcap_32
XFILLER_47_146 VDD VDD VSS VSS gf180mcu_fd_sc_mcu7t5v0__fill_1
XFILLER_75_488 VDD VDD VSS VSS gf180mcu_fd_sc_mcu7t5v0__fill_2
XTAP_TAPCELL_ROW_18_517 VDD VSS gf180mcu_fd_sc_mcu7t5v0__filltie
XFILLER_16_533 VDD VDD VSS VSS gf180mcu_fd_sc_mcu7t5v0__fillcap_16
XFILLER_43_352 VDD VDD VSS VSS gf180mcu_fd_sc_mcu7t5v0__fillcap_16
XFILLER_44_864 VDD VDD VSS VSS gf180mcu_fd_sc_mcu7t5v0__fill_2
XFILLER_43_374 VDD VDD VSS VSS gf180mcu_fd_sc_mcu7t5v0__fill_1
XFILLER_70_171 VDD VDD VSS VSS gf180mcu_fd_sc_mcu7t5v0__fillcap_4
XFILLER_70_193 VDD VDD VSS VSS gf180mcu_fd_sc_mcu7t5v0__fill_1
XFILLER_129_424 VDD VDD VSS VSS gf180mcu_fd_sc_mcu7t5v0__fill_1
XTAP_TAPCELL_ROW_100_1589 VDD VSS gf180mcu_fd_sc_mcu7t5v0__filltie
XFILLER_11_282 VDD VDD VSS VSS gf180mcu_fd_sc_mcu7t5v0__fillcap_4
XFILLER_116_107 VDD VDD VSS VSS gf180mcu_fd_sc_mcu7t5v0__fillcap_4
Xhold209 s_axi_wdata[16] hold209/Z VDD VDD VSS VSS gf180mcu_fd_sc_mcu7t5v0__dlyc_1
X_3330_ _3316_/Z _3332_/B2 _3335_/B _3332_/A2 VDD VDD VSS VSS gf180mcu_fd_sc_mcu7t5v0__oai21_1
XTAP_TAPCELL_ROW_55_1002 VDD VSS gf180mcu_fd_sc_mcu7t5v0__filltie
XFILLER_98_569 VDD VDD VSS VSS gf180mcu_fd_sc_mcu7t5v0__fillcap_16
X_3261_ _3904_/Q _4062_/Q _3261_/Z VDD VDD VSS VSS gf180mcu_fd_sc_mcu7t5v0__xor2_1
XFILLER_3_492 VDD VDD VSS VSS gf180mcu_fd_sc_mcu7t5v0__fillcap_64
X_3192_ _4035_/Q _4003_/Q _4129_/D _4035_/D VDD VDD VSS VSS gf180mcu_fd_sc_mcu7t5v0__mux2_2
XFILLER_79_772 VDD VDD VSS VSS gf180mcu_fd_sc_mcu7t5v0__fillcap_64
X_2212_ _3660_/Q _3668_/Q _3676_/Q _3684_/Q place79/Z place78/Z _2212_/Z VDD VDD VSS
+ VSS gf180mcu_fd_sc_mcu7t5v0__mux4_1
XFILLER_66_411 VDD VDD VSS VSS gf180mcu_fd_sc_mcu7t5v0__fill_1
XFILLER_67_912 VDD VDD VSS VSS gf180mcu_fd_sc_mcu7t5v0__fillcap_16
XFILLER_94_731 VDD VDD VSS VSS gf180mcu_fd_sc_mcu7t5v0__fillcap_4
XFILLER_15_2 VDD VDD VSS VSS gf180mcu_fd_sc_mcu7t5v0__fillcap_64
X_2143_ _3631_/Q _3687_/Q _3695_/Q _3703_/Q place79/Z place78/Z _2143_/Z VDD VDD VSS
+ VSS gf180mcu_fd_sc_mcu7t5v0__mux4_1
X_2074_ _2079_/A1 _2074_/A2 _2074_/Z VDD VDD VSS VSS gf180mcu_fd_sc_mcu7t5v0__xor2_1
XFILLER_35_842 VDD VDD VSS VSS gf180mcu_fd_sc_mcu7t5v0__fillcap_16
XFILLER_53_138 VDD VDD VSS VSS gf180mcu_fd_sc_mcu7t5v0__fill_2
XFILLER_62_650 VDD VDD VSS VSS gf180mcu_fd_sc_mcu7t5v0__fillcap_8
XTAP_TAPCELL_ROW_66_1142 VDD VSS gf180mcu_fd_sc_mcu7t5v0__filltie
XTAP_TAPCELL_ROW_45_870 VDD VSS gf180mcu_fd_sc_mcu7t5v0__filltie
XFILLER_50_823 VDD VDD VSS VSS gf180mcu_fd_sc_mcu7t5v0__fillcap_8
XFILLER_61_160 VDD VDD VSS VSS gf180mcu_fd_sc_mcu7t5v0__fill_1
XFILLER_22_547 VDD VDD VSS VSS gf180mcu_fd_sc_mcu7t5v0__fillcap_16
XTAP_TAPCELL_ROW_118_1817 VDD VSS gf180mcu_fd_sc_mcu7t5v0__filltie
X_1927_ _3895_/Q _1927_/A2 _1927_/A3 _1927_/Z VDD VDD VSS VSS gf180mcu_fd_sc_mcu7t5v0__and3_1
XFILLER_30_591 VDD VDD VSS VSS gf180mcu_fd_sc_mcu7t5v0__fillcap_4
X_1858_ _4140_/Q _1858_/A2 _1858_/B1 _1858_/B2 _1859_/B VDD VDD VSS VSS gf180mcu_fd_sc_mcu7t5v0__aoi22_1
XFILLER_104_803 VDD VDD VSS VSS gf180mcu_fd_sc_mcu7t5v0__fill_2
XTAP_TAPCELL_ROW_77_1282 VDD VSS gf180mcu_fd_sc_mcu7t5v0__filltie
XTAP_TAPCELL_ROW_77_1293 VDD VSS gf180mcu_fd_sc_mcu7t5v0__filltie
X_3528_ place75/Z place76/Z _3500_/I _3529_/A2 VDD VDD VSS VSS gf180mcu_fd_sc_mcu7t5v0__nand3_1
XFILLER_103_368 VDD VDD VSS VSS gf180mcu_fd_sc_mcu7t5v0__fill_1
XTAP_TAPCELL_ROW_90_1460 VDD VSS gf180mcu_fd_sc_mcu7t5v0__filltie
XFILLER_39_48 VDD VDD VSS VSS gf180mcu_fd_sc_mcu7t5v0__fill_2
X_3459_ _3459_/A1 _2182_/Z _3476_/B VDD VDD VSS VSS gf180mcu_fd_sc_mcu7t5v0__nor2_1
XFILLER_131_699 VDD VDD VSS VSS gf180mcu_fd_sc_mcu7t5v0__fill_1
XFILLER_103_379 VDD VDD VSS VSS gf180mcu_fd_sc_mcu7t5v0__fillcap_32
XTAP_TAPCELL_ROW_129_1957 VDD VSS gf180mcu_fd_sc_mcu7t5v0__filltie
XFILLER_57_422 VDD VDD VSS VSS gf180mcu_fd_sc_mcu7t5v0__fillcap_32
XFILLER_69_282 VDD VDD VSS VSS gf180mcu_fd_sc_mcu7t5v0__fillcap_8
XTAP_TAPCELL_ROW_129_1968 VDD VSS gf180mcu_fd_sc_mcu7t5v0__filltie
XFILLER_84_263 VDD VDD VSS VSS gf180mcu_fd_sc_mcu7t5v0__fillcap_4
XFILLER_55_69 VDD VDD VSS VSS gf180mcu_fd_sc_mcu7t5v0__fill_1
XFILLER_25_341 VDD VDD VSS VSS gf180mcu_fd_sc_mcu7t5v0__fillcap_8
XFILLER_25_352 VDD VDD VSS VSS gf180mcu_fd_sc_mcu7t5v0__fillcap_64
XFILLER_53_661 VDD VDD VSS VSS gf180mcu_fd_sc_mcu7t5v0__fill_2
XFILLER_111_64 VDD VDD VSS VSS gf180mcu_fd_sc_mcu7t5v0__fillcap_4
XFILLER_13_536 VDD VDD VSS VSS gf180mcu_fd_sc_mcu7t5v0__fillcap_16
XFILLER_40_333 VDD VDD VSS VSS gf180mcu_fd_sc_mcu7t5v0__fillcap_8
XFILLER_52_193 VDD VDD VSS VSS gf180mcu_fd_sc_mcu7t5v0__fill_2
XFILLER_71_46 VDD VDD VSS VSS gf180mcu_fd_sc_mcu7t5v0__fill_2
XFILLER_127_906 VDD VDD VSS VSS gf180mcu_fd_sc_mcu7t5v0__fillcap_4
XTAP_TAPCELL_ROW_23_586 VDD VSS gf180mcu_fd_sc_mcu7t5v0__filltie
XFILLER_127_928 VDD VDD VSS VSS gf180mcu_fd_sc_mcu7t5v0__fillcap_4
XFILLER_5_702 VDD VDD VSS VSS gf180mcu_fd_sc_mcu7t5v0__fillcap_8
XFILLER_4_234 VDD VDD VSS VSS gf180mcu_fd_sc_mcu7t5v0__fillcap_8
XFILLER_48_411 VDD VDD VSS VSS gf180mcu_fd_sc_mcu7t5v0__fillcap_4
XFILLER_49_912 VDD VDD VSS VSS gf180mcu_fd_sc_mcu7t5v0__fillcap_16
XFILLER_88_591 VDD VDD VSS VSS gf180mcu_fd_sc_mcu7t5v0__fillcap_4
XFILLER_91_734 VDD VDD VSS VSS gf180mcu_fd_sc_mcu7t5v0__fillcap_32
XFILLER_63_414 VDD VDD VSS VSS gf180mcu_fd_sc_mcu7t5v0__fillcap_4
XFILLER_17_864 VDD VDD VSS VSS gf180mcu_fd_sc_mcu7t5v0__fillcap_32
XFILLER_17_842 VDD VDD VSS VSS gf180mcu_fd_sc_mcu7t5v0__fillcap_4
XPHY_EDGE_ROW_11_Left_144 VDD VSS gf180mcu_fd_sc_mcu7t5v0__endcap
XTAP_TAPCELL_ROW_102_1618 VDD VSS gf180mcu_fd_sc_mcu7t5v0__filltie
XTAP_TAPCELL_ROW_102_1607 VDD VSS gf180mcu_fd_sc_mcu7t5v0__filltie
XFILLER_32_801 VDD VDD VSS VSS gf180mcu_fd_sc_mcu7t5v0__fillcap_4
XFILLER_32_823 VDD VDD VSS VSS gf180mcu_fd_sc_mcu7t5v0__fillcap_4
XFILLER_31_322 VDD VDD VSS VSS gf180mcu_fd_sc_mcu7t5v0__fillcap_4
XFILLER_32_856 VDD VDD VSS VSS gf180mcu_fd_sc_mcu7t5v0__fillcap_16
XTAP_TAPCELL_ROW_61_1083 VDD VSS gf180mcu_fd_sc_mcu7t5v0__filltie
XFILLER_118_928 VDD VDD VSS VSS gf180mcu_fd_sc_mcu7t5v0__fillcap_4
XFILLER_117_416 VDD VDD VSS VSS gf180mcu_fd_sc_mcu7t5v0__fillcap_4
XANTENNA_1 _2124_/ZN VDD VDD VSS VSS gf180mcu_fd_sc_mcu7t5v0__antenna
XPHY_EDGE_ROW_20_Left_153 VDD VSS gf180mcu_fd_sc_mcu7t5v0__endcap
XTAP_TAPCELL_ROW_113_1758 VDD VSS gf180mcu_fd_sc_mcu7t5v0__filltie
XFILLER_113_622 VDD VDD VSS VSS gf180mcu_fd_sc_mcu7t5v0__fillcap_8
XFILLER_98_311 VDD VDD VSS VSS gf180mcu_fd_sc_mcu7t5v0__fillcap_4
X_3313_ _4075_/Q _3326_/A1 VDD VDD VSS VSS gf180mcu_fd_sc_mcu7t5v0__clkinv_1
XFILLER_100_305 VDD VDD VSS VSS gf180mcu_fd_sc_mcu7t5v0__fillcap_8
XFILLER_39_422 VDD VDD VSS VSS gf180mcu_fd_sc_mcu7t5v0__fillcap_8
X_3175_ _4027_/Q _3995_/Q _4129_/D _4027_/D VDD VDD VSS VSS gf180mcu_fd_sc_mcu7t5v0__mux2_2
XFILLER_54_403 VDD VDD VSS VSS gf180mcu_fd_sc_mcu7t5v0__fillcap_8
X_2126_ _3710_/Q _3718_/Q _3726_/Q _3734_/Q place79/Z place78/Z _2126_/Z VDD VDD VSS
+ VSS gf180mcu_fd_sc_mcu7t5v0__mux4_1
X_2057_ _2079_/A2 _2079_/A3 _2063_/A2 VDD VDD VSS VSS gf180mcu_fd_sc_mcu7t5v0__nor2_1
XFILLER_70_929 VDD VDD VSS VSS gf180mcu_fd_sc_mcu7t5v0__fillcap_4
XFILLER_23_801 VDD VDD VSS VSS gf180mcu_fd_sc_mcu7t5v0__fillcap_8
XTAP_TAPCELL_ROW_124_1898 VDD VSS gf180mcu_fd_sc_mcu7t5v0__filltie
XFILLER_109_928 VDD VDD VSS VSS gf180mcu_fd_sc_mcu7t5v0__fillcap_4
XTAP_TAPCELL_ROW_79_1311 VDD VSS gf180mcu_fd_sc_mcu7t5v0__filltie
XTAP_TAPCELL_ROW_20_545 VDD VSS gf180mcu_fd_sc_mcu7t5v0__filltie
XFILLER_132_920 VDD VDD VSS VSS gf180mcu_fd_sc_mcu7t5v0__fillcap_8
XFILLER_104_699 VDD VDD VSS VSS gf180mcu_fd_sc_mcu7t5v0__fillcap_8
XFILLER_85_572 VDD VDD VSS VSS gf180mcu_fd_sc_mcu7t5v0__fill_2
XFILLER_66_68 VDD VDD VSS VSS gf180mcu_fd_sc_mcu7t5v0__fillcap_8
XFILLER_73_767 VDD VDD VSS VSS gf180mcu_fd_sc_mcu7t5v0__fill_2
XFILLER_17_138 VDD VDD VSS VSS gf180mcu_fd_sc_mcu7t5v0__fill_2
XTAP_TAPCELL_ROW_28_645 VDD VSS gf180mcu_fd_sc_mcu7t5v0__filltie
XTAP_TAPCELL_ROW_28_656 VDD VSS gf180mcu_fd_sc_mcu7t5v0__filltie
XFILLER_45_469 VDD VDD VSS VSS gf180mcu_fd_sc_mcu7t5v0__fillcap_4
XFILLER_72_244 VDD VDD VSS VSS gf180mcu_fd_sc_mcu7t5v0__fill_1
XFILLER_82_56 VDD VDD VSS VSS gf180mcu_fd_sc_mcu7t5v0__fill_2
XTAP_TAPCELL_ROW_0_281 VDD VSS gf180mcu_fd_sc_mcu7t5v0__filltie
XTAP_TAPCELL_ROW_0_270 VDD VSS gf180mcu_fd_sc_mcu7t5v0__filltie
XFILLER_26_683 VDD VDD VSS VSS gf180mcu_fd_sc_mcu7t5v0__fill_2
XTAP_TAPCELL_ROW_0_292 VDD VSS gf180mcu_fd_sc_mcu7t5v0__filltie
XFILLER_14_889 VDD VDD VSS VSS gf180mcu_fd_sc_mcu7t5v0__fill_2
XFILLER_40_174 VDD VDD VSS VSS gf180mcu_fd_sc_mcu7t5v0__fill_1
XFILLER_126_202 VDD VDD VSS VSS gf180mcu_fd_sc_mcu7t5v0__fillcap_4
XFILLER_126_224 VDD VDD VSS VSS gf180mcu_fd_sc_mcu7t5v0__fillcap_16
XFILLER_127_769 VDD VDD VSS VSS gf180mcu_fd_sc_mcu7t5v0__fill_1
XFILLER_115_909 VDD VDD VSS VSS gf180mcu_fd_sc_mcu7t5v0__fill_1
XPHY_EDGE_ROW_128_Right_128 VDD VSS gf180mcu_fd_sc_mcu7t5v0__endcap
XFILLER_99_119 VDD VDD VSS VSS gf180mcu_fd_sc_mcu7t5v0__fillcap_16
XFILLER_122_430 VDD VDD VSS VSS gf180mcu_fd_sc_mcu7t5v0__fill_2
XFILLER_95_325 VDD VDD VSS VSS gf180mcu_fd_sc_mcu7t5v0__fillcap_16
XTAP_TAPCELL_ROW_8_392 VDD VSS gf180mcu_fd_sc_mcu7t5v0__filltie
XFILLER_76_561 VDD VDD VSS VSS gf180mcu_fd_sc_mcu7t5v0__fillcap_32
XFILLER_48_241 VDD VDD VSS VSS gf180mcu_fd_sc_mcu7t5v0__fillcap_4
XFILLER_48_263 VDD VDD VSS VSS gf180mcu_fd_sc_mcu7t5v0__fillcap_4
XFILLER_52_929 VDD VDD VSS VSS gf180mcu_fd_sc_mcu7t5v0__fillcap_4
XTAP_TAPCELL_ROW_63_1101 VDD VSS gf180mcu_fd_sc_mcu7t5v0__filltie
X_3931_ _3931_/D _2279_/I _4128_/CLK _3931_/Q VDD VDD VSS VSS gf180mcu_fd_sc_mcu7t5v0__dffrnq_1
XFILLER_16_171 VDD VDD VSS VSS gf180mcu_fd_sc_mcu7t5v0__fillcap_4
X_3862_ _3862_/D clkload7/I _3862_/Q VDD VDD VSS VSS gf180mcu_fd_sc_mcu7t5v0__dffq_1
XFILLER_31_130 VDD VDD VSS VSS gf180mcu_fd_sc_mcu7t5v0__fillcap_8
XFILLER_32_664 VDD VDD VSS VSS gf180mcu_fd_sc_mcu7t5v0__fill_1
X_3793_ _3793_/D _3864_/CLK _3793_/Q VDD VDD VSS VSS gf180mcu_fd_sc_mcu7t5v0__dffq_1
X_2744_ _3827_/Q place84/Z _2746_/S _3827_/D VDD VDD VSS VSS gf180mcu_fd_sc_mcu7t5v0__mux2_2
XFILLER_8_381 VDD VDD VSS VSS gf180mcu_fd_sc_mcu7t5v0__fillcap_4
XTAP_TAPCELL_ROW_74_1252 VDD VSS gf180mcu_fd_sc_mcu7t5v0__filltie
XFILLER_98_141 VDD VDD VSS VSS gf180mcu_fd_sc_mcu7t5v0__fillcap_32
XFILLER_86_325 VDD VDD VSS VSS gf180mcu_fd_sc_mcu7t5v0__fillcap_4
X_3227_ _4052_/Q _4020_/Q _4129_/D _4052_/D VDD VDD VSS VSS gf180mcu_fd_sc_mcu7t5v0__mux2_2
XTAP_TAPCELL_ROW_126_1927 VDD VSS gf180mcu_fd_sc_mcu7t5v0__filltie
X_3158_ _4019_/Q _3158_/I1 _3160_/S _4019_/D VDD VDD VSS VSS gf180mcu_fd_sc_mcu7t5v0__mux2_2
X_2109_ _2109_/I _2110_/A2 VDD VDD VSS VSS gf180mcu_fd_sc_mcu7t5v0__clkinv_1
XFILLER_82_597 VDD VDD VSS VSS gf180mcu_fd_sc_mcu7t5v0__fillcap_16
XFILLER_82_575 VDD VDD VSS VSS gf180mcu_fd_sc_mcu7t5v0__fill_2
XTAP_TAPCELL_ROW_25_615 VDD VSS gf180mcu_fd_sc_mcu7t5v0__filltie
XFILLER_70_737 VDD VDD VSS VSS gf180mcu_fd_sc_mcu7t5v0__fillcap_64
XTAP_TAPCELL_ROW_85_1392 VDD VSS gf180mcu_fd_sc_mcu7t5v0__filltie
XFILLER_11_804 VDD VDD VSS VSS gf180mcu_fd_sc_mcu7t5v0__fillcap_16
XFILLER_23_664 VDD VDD VSS VSS gf180mcu_fd_sc_mcu7t5v0__fillcap_8
XFILLER_52_37 VDD VDD VSS VSS gf180mcu_fd_sc_mcu7t5v0__fillcap_16
XTAP_TAPCELL_ROW_53_979 VDD VSS gf180mcu_fd_sc_mcu7t5v0__filltie
XFILLER_117_780 VDD VDD VSS VSS gf180mcu_fd_sc_mcu7t5v0__fillcap_4
XFILLER_2_524 VDD VDD VSS VSS gf180mcu_fd_sc_mcu7t5v0__fill_1
XFILLER_117_52 VDD VDD VSS VSS gf180mcu_fd_sc_mcu7t5v0__fill_2
XFILLER_131_282 VDD VDD VSS VSS gf180mcu_fd_sc_mcu7t5v0__fillcap_64
XTAP_TAPCELL_ROW_5_351 VDD VSS gf180mcu_fd_sc_mcu7t5v0__filltie
XFILLER_58_572 VDD VDD VSS VSS gf180mcu_fd_sc_mcu7t5v0__fillcap_4
XFILLER_58_594 VDD VDD VSS VSS gf180mcu_fd_sc_mcu7t5v0__fill_1
XFILLER_73_586 VDD VDD VSS VSS gf180mcu_fd_sc_mcu7t5v0__fill_1
XFILLER_61_737 VDD VDD VSS VSS gf180mcu_fd_sc_mcu7t5v0__fill_1
XFILLER_13_196 VDD VDD VSS VSS gf180mcu_fd_sc_mcu7t5v0__fillcap_8
X_2460_ _4071_/Q _3705_/Q _2466_/S _3705_/D VDD VDD VSS VSS gf180mcu_fd_sc_mcu7t5v0__mux2_2
XFILLER_123_772 VDD VDD VSS VSS gf180mcu_fd_sc_mcu7t5v0__fillcap_64
X_4130_ _4130_/D input92/Z _4130_/CLK _4130_/Q VDD VDD VSS VSS gf180mcu_fd_sc_mcu7t5v0__dffrnq_1
XFILLER_111_912 VDD VDD VSS VSS gf180mcu_fd_sc_mcu7t5v0__fillcap_16
XTAP_TAPCELL_ROW_110_1717 VDD VSS gf180mcu_fd_sc_mcu7t5v0__filltie
X_2391_ _3674_/Q place80/Z _2395_/S _3674_/D VDD VDD VSS VSS gf180mcu_fd_sc_mcu7t5v0__mux2_2
XFILLER_68_314 VDD VDD VSS VSS gf180mcu_fd_sc_mcu7t5v0__fill_1
X_4061_ _4061_/D input92/Z _4130_/CLK _4061_/Q VDD VDD VSS VSS gf180mcu_fd_sc_mcu7t5v0__dffrnq_1
XFILLER_96_667 VDD VDD VSS VSS gf180mcu_fd_sc_mcu7t5v0__fillcap_16
XFILLER_84_807 VDD VDD VSS VSS gf180mcu_fd_sc_mcu7t5v0__fillcap_8
X_3012_ _3950_/Q _4038_/Q _3041_/S _3950_/D VDD VDD VSS VSS gf180mcu_fd_sc_mcu7t5v0__mux2_2
XFILLER_91_372 VDD VDD VSS VSS gf180mcu_fd_sc_mcu7t5v0__fillcap_4
XFILLER_36_255 VDD VDD VSS VSS gf180mcu_fd_sc_mcu7t5v0__fill_1
XFILLER_36_288 VDD VDD VSS VSS gf180mcu_fd_sc_mcu7t5v0__fillcap_16
XFILLER_64_597 VDD VDD VSS VSS gf180mcu_fd_sc_mcu7t5v0__fillcap_64
X_3914_ _3914_/D _4157_/RN _3946_/CLK _3914_/Q VDD VDD VSS VSS gf180mcu_fd_sc_mcu7t5v0__dffrnq_1
XTAP_TAPCELL_ROW_121_1857 VDD VSS gf180mcu_fd_sc_mcu7t5v0__filltie
XTAP_TAPCELL_ROW_50_938 VDD VSS gf180mcu_fd_sc_mcu7t5v0__filltie
X_3845_ _3845_/D _3866_/CLK _3845_/Q VDD VDD VSS VSS gf180mcu_fd_sc_mcu7t5v0__dffq_1
XFILLER_20_667 VDD VDD VSS VSS gf180mcu_fd_sc_mcu7t5v0__fillcap_8
XTAP_TAPCELL_ROW_30_673 VDD VSS gf180mcu_fd_sc_mcu7t5v0__filltie
X_3776_ _3776_/D clkload8/I _3776_/Q VDD VDD VSS VSS gf180mcu_fd_sc_mcu7t5v0__dffq_1
XFILLER_105_205 VDD VDD VSS VSS gf180mcu_fd_sc_mcu7t5v0__fillcap_4
X_2658_ place83/Z _3788_/Q _2658_/S _3788_/D VDD VDD VSS VSS gf180mcu_fd_sc_mcu7t5v0__mux2_2
XTAP_TAPCELL_ROW_132_1997 VDD VSS gf180mcu_fd_sc_mcu7t5v0__filltie
XFILLER_113_282 VDD VDD VSS VSS gf180mcu_fd_sc_mcu7t5v0__fill_2
XFILLER_101_422 VDD VDD VSS VSS gf180mcu_fd_sc_mcu7t5v0__fill_2
XFILLER_86_177 VDD VDD VSS VSS gf180mcu_fd_sc_mcu7t5v0__fillcap_4
XFILLER_74_317 VDD VDD VSS VSS gf180mcu_fd_sc_mcu7t5v0__fill_2
XTAP_TAPCELL_ROW_2_310 VDD VSS gf180mcu_fd_sc_mcu7t5v0__filltie
XTAP_TAPCELL_ROW_87_1421 VDD VSS gf180mcu_fd_sc_mcu7t5v0__filltie
XFILLER_55_520 VDD VDD VSS VSS gf180mcu_fd_sc_mcu7t5v0__fillcap_4
XFILLER_55_542 VDD VDD VSS VSS gf180mcu_fd_sc_mcu7t5v0__fillcap_4
XFILLER_27_277 VDD VDD VSS VSS gf180mcu_fd_sc_mcu7t5v0__fill_2
XFILLER_103_98 VDD VDD VSS VSS gf180mcu_fd_sc_mcu7t5v0__fill_1
XTAP_TAPCELL_ROW_38_784 VDD VSS gf180mcu_fd_sc_mcu7t5v0__filltie
XFILLER_63_58 VDD VDD VSS VSS gf180mcu_fd_sc_mcu7t5v0__fillcap_8
XFILLER_42_247 VDD VDD VSS VSS gf180mcu_fd_sc_mcu7t5v0__fillcap_64
XFILLER_109_500 VDD VDD VSS VSS gf180mcu_fd_sc_mcu7t5v0__fillcap_4
XTAP_TAPCELL_ROW_98_1561 VDD VSS gf180mcu_fd_sc_mcu7t5v0__filltie
XFILLER_2_321 VDD VDD VSS VSS gf180mcu_fd_sc_mcu7t5v0__fill_2
XFILLER_105_772 VDD VDD VSS VSS gf180mcu_fd_sc_mcu7t5v0__fillcap_16
XFILLER_2_387 VDD VDD VSS VSS gf180mcu_fd_sc_mcu7t5v0__fillcap_4
XFILLER_78_667 VDD VDD VSS VSS gf180mcu_fd_sc_mcu7t5v0__fillcap_64
XFILLER_66_807 VDD VDD VSS VSS gf180mcu_fd_sc_mcu7t5v0__fillcap_64
XFILLER_92_147 VDD VDD VSS VSS gf180mcu_fd_sc_mcu7t5v0__fill_1
XFILLER_18_255 VDD VDD VSS VSS gf180mcu_fd_sc_mcu7t5v0__fill_1
XFILLER_34_737 VDD VDD VSS VSS gf180mcu_fd_sc_mcu7t5v0__fillcap_32
XFILLER_46_597 VDD VDD VSS VSS gf180mcu_fd_sc_mcu7t5v0__fillcap_32
XFILLER_61_556 VDD VDD VSS VSS gf180mcu_fd_sc_mcu7t5v0__fillcap_4
X_1960_ _4061_/Q _3249_/A1 VDD VDD VSS VSS gf180mcu_fd_sc_mcu7t5v0__clkinv_1
XTAP_TAPCELL_ROW_16_489 VDD VSS gf180mcu_fd_sc_mcu7t5v0__filltie
XFILLER_119_319 VDD VDD VSS VSS gf180mcu_fd_sc_mcu7t5v0__fillcap_16
X_1891_ _2041_/A1 _1822_/Z _1892_/A2 VDD VDD VSS VSS gf180mcu_fd_sc_mcu7t5v0__nand2_1
X_3630_ _3630_/D _4072_/CLK _3630_/Q VDD VDD VSS VSS gf180mcu_fd_sc_mcu7t5v0__dffq_1
X_3561_ _3839_/Q _3847_/Q _3855_/Q _3863_/Q place76/Z place75/Z _3561_/Z VDD VDD VSS
+ VSS gf180mcu_fd_sc_mcu7t5v0__mux4_1
XFILLER_127_352 VDD VDD VSS VSS gf180mcu_fd_sc_mcu7t5v0__fillcap_16
X_3492_ _4151_/Q _4153_/Q _3491_/Z _3492_/Z VDD VDD VSS VSS gf180mcu_fd_sc_mcu7t5v0__xor3_1
XTAP_TAPCELL_ROW_58_1044 VDD VSS gf180mcu_fd_sc_mcu7t5v0__filltie
XTAP_TAPCELL_ROW_71_1211 VDD VSS gf180mcu_fd_sc_mcu7t5v0__filltie
XFILLER_45_2 VDD VDD VSS VSS gf180mcu_fd_sc_mcu7t5v0__fillcap_4
XFILLER_97_932 VDD VDD VSS VSS gf180mcu_fd_sc_mcu7t5v0__fill_2
X_4113_ _4113_/D _2279_/I _4114_/CLK _4113_/Q VDD VDD VSS VSS gf180mcu_fd_sc_mcu7t5v0__dffrnq_1
XFILLER_110_263 VDD VDD VSS VSS gf180mcu_fd_sc_mcu7t5v0__fill_2
XFILLER_96_475 VDD VDD VSS VSS gf180mcu_fd_sc_mcu7t5v0__fill_1
XPHY_EDGE_ROW_3_Left_136 VDD VSS gf180mcu_fd_sc_mcu7t5v0__endcap
XFILLER_68_177 VDD VDD VSS VSS gf180mcu_fd_sc_mcu7t5v0__fillcap_64
X_4044_ _4044_/D _4148_/RN _4146_/CLK _4044_/Q VDD VDD VSS VSS gf180mcu_fd_sc_mcu7t5v0__dffrnq_1
XFILLER_84_659 VDD VDD VSS VSS gf180mcu_fd_sc_mcu7t5v0__fillcap_4
XFILLER_83_136 VDD VDD VSS VSS gf180mcu_fd_sc_mcu7t5v0__fillcap_4
XFILLER_37_542 VDD VDD VSS VSS gf180mcu_fd_sc_mcu7t5v0__fillcap_16
XTAP_TAPCELL_ROW_69_1184 VDD VSS gf180mcu_fd_sc_mcu7t5v0__filltie
XFILLER_24_247 VDD VDD VSS VSS gf180mcu_fd_sc_mcu7t5v0__fill_2
XTAP_TAPCELL_ROW_35_743 VDD VSS gf180mcu_fd_sc_mcu7t5v0__filltie
XTAP_TAPCELL_ROW_82_1351 VDD VSS gf180mcu_fd_sc_mcu7t5v0__filltie
XFILLER_21_932 VDD VDD VSS VSS gf180mcu_fd_sc_mcu7t5v0__fill_2
XFILLER_119_820 VDD VDD VSS VSS gf180mcu_fd_sc_mcu7t5v0__fillcap_16
X_3828_ _3828_/D _4112_/CLK _3828_/Q VDD VDD VSS VSS gf180mcu_fd_sc_mcu7t5v0__dffq_1
XFILLER_119_842 VDD VDD VSS VSS gf180mcu_fd_sc_mcu7t5v0__fill_1
X_3759_ _3759_/D _4159_/CLK _3759_/Q VDD VDD VSS VSS gf180mcu_fd_sc_mcu7t5v0__dffq_1
XFILLER_4_608 VDD VDD VSS VSS gf180mcu_fd_sc_mcu7t5v0__fill_1
XFILLER_114_591 VDD VDD VSS VSS gf180mcu_fd_sc_mcu7t5v0__fillcap_4
XTAP_TAPCELL_ROW_93_1491 VDD VSS gf180mcu_fd_sc_mcu7t5v0__filltie
XFILLER_59_100 VDD VDD VSS VSS gf180mcu_fd_sc_mcu7t5v0__fill_1
XFILLER_87_442 VDD VDD VSS VSS gf180mcu_fd_sc_mcu7t5v0__fillcap_32
XFILLER_48_807 VDD VDD VSS VSS gf180mcu_fd_sc_mcu7t5v0__fillcap_16
XFILLER_74_103 VDD VDD VSS VSS gf180mcu_fd_sc_mcu7t5v0__fill_2
XFILLER_47_328 VDD VDD VSS VSS gf180mcu_fd_sc_mcu7t5v0__fill_1
XFILLER_90_629 VDD VDD VSS VSS gf180mcu_fd_sc_mcu7t5v0__fillcap_16
XFILLER_28_564 VDD VDD VSS VSS gf180mcu_fd_sc_mcu7t5v0__fillcap_16
XFILLER_16_737 VDD VDD VSS VSS gf180mcu_fd_sc_mcu7t5v0__fillcap_32
XFILLER_28_597 VDD VDD VSS VSS gf180mcu_fd_sc_mcu7t5v0__fillcap_8
XFILLER_71_854 VDD VDD VSS VSS gf180mcu_fd_sc_mcu7t5v0__fill_2
XFILLER_70_364 VDD VDD VSS VSS gf180mcu_fd_sc_mcu7t5v0__fill_2
XFILLER_129_628 VDD VDD VSS VSS gf180mcu_fd_sc_mcu7t5v0__fill_2
XFILLER_128_127 VDD VDD VSS VSS gf180mcu_fd_sc_mcu7t5v0__fillcap_32
XFILLER_90_89 VDD VDD VSS VSS gf180mcu_fd_sc_mcu7t5v0__fill_1
XTAP_TAPCELL_ROW_13_459 VDD VSS gf180mcu_fd_sc_mcu7t5v0__filltie
XFILLER_8_925 VDD VDD VSS VSS gf180mcu_fd_sc_mcu7t5v0__fillcap_8
XFILLER_7_402 VDD VDD VSS VSS gf180mcu_fd_sc_mcu7t5v0__fill_1
XFILLER_23_72 VDD VDD VSS VSS gf180mcu_fd_sc_mcu7t5v0__fillcap_16
XFILLER_109_352 VDD VDD VSS VSS gf180mcu_fd_sc_mcu7t5v0__fillcap_16
XFILLER_99_87 VDD VDD VSS VSS gf180mcu_fd_sc_mcu7t5v0__fillcap_32
XFILLER_124_377 VDD VDD VSS VSS gf180mcu_fd_sc_mcu7t5v0__fill_2
XFILLER_79_932 VDD VDD VSS VSS gf180mcu_fd_sc_mcu7t5v0__fill_2
XFILLER_120_561 VDD VDD VSS VSS gf180mcu_fd_sc_mcu7t5v0__fillcap_32
XFILLER_38_317 VDD VDD VSS VSS gf180mcu_fd_sc_mcu7t5v0__fillcap_16
X_2090_ _4146_/Q _2095_/A2 _2091_/A2 VDD VDD VSS VSS gf180mcu_fd_sc_mcu7t5v0__xnor2_1
XFILLER_47_884 VDD VDD VSS VSS gf180mcu_fd_sc_mcu7t5v0__fillcap_16
XFILLER_65_158 VDD VDD VSS VSS gf180mcu_fd_sc_mcu7t5v0__fillcap_8
XFILLER_80_139 VDD VDD VSS VSS gf180mcu_fd_sc_mcu7t5v0__fillcap_16
XTAP_TAPCELL_ROW_105_1649 VDD VSS gf180mcu_fd_sc_mcu7t5v0__filltie
XFILLER_34_556 VDD VDD VSS VSS gf180mcu_fd_sc_mcu7t5v0__fillcap_32
XTAP_TAPCELL_ROW_32_702 VDD VSS gf180mcu_fd_sc_mcu7t5v0__filltie
X_1943_ _3898_/Q _1943_/A2 _1943_/B1 _1943_/B2 _1943_/C _1944_/C VDD VDD VSS VSS gf180mcu_fd_sc_mcu7t5v0__aoi221_4
X_1874_ _3889_/Q _4136_/Q _1935_/A4 _1878_/A1 VDD VDD VSS VSS gf180mcu_fd_sc_mcu7t5v0__nand3_1
XFILLER_115_322 VDD VDD VSS VSS gf180mcu_fd_sc_mcu7t5v0__fill_1
XFILLER_116_889 VDD VDD VSS VSS gf180mcu_fd_sc_mcu7t5v0__fill_2
XTAP_TAPCELL_ROW_116_1789 VDD VSS gf180mcu_fd_sc_mcu7t5v0__filltie
XFILLER_89_718 VDD VDD VSS VSS gf180mcu_fd_sc_mcu7t5v0__fill_2
XFILLER_88_206 VDD VDD VSS VSS gf180mcu_fd_sc_mcu7t5v0__fill_2
X_3475_ _4107_/Q _3475_/A2 _3469_/Z _3475_/B _4107_/D VDD VDD VSS VSS gf180mcu_fd_sc_mcu7t5v0__oai31_2
X_2426_ _3690_/Q place80/Z _2430_/S _3690_/D VDD VDD VSS VSS gf180mcu_fd_sc_mcu7t5v0__mux2_2
X_2357_ _3660_/Q _4074_/Q _2357_/S _3660_/D VDD VDD VSS VSS gf180mcu_fd_sc_mcu7t5v0__mux2_2
XFILLER_57_626 VDD VDD VSS VSS gf180mcu_fd_sc_mcu7t5v0__fillcap_4
X_2288_ _3631_/Q _4069_/Q _2298_/S _3631_/D VDD VDD VSS VSS gf180mcu_fd_sc_mcu7t5v0__mux2_2
XFILLER_84_489 VDD VDD VSS VSS gf180mcu_fd_sc_mcu7t5v0__fillcap_32
X_4027_ _4027_/D input92/Z _4028_/CLK _4027_/Q VDD VDD VSS VSS gf180mcu_fd_sc_mcu7t5v0__dffrnq_1
XFILLER_71_139 VDD VDD VSS VSS gf180mcu_fd_sc_mcu7t5v0__fill_1
XFILLER_25_556 VDD VDD VSS VSS gf180mcu_fd_sc_mcu7t5v0__fillcap_4
XFILLER_44_27 VDD VDD VSS VSS gf180mcu_fd_sc_mcu7t5v0__fillcap_8
XFILLER_53_854 VDD VDD VSS VSS gf180mcu_fd_sc_mcu7t5v0__fill_2
XFILLER_13_718 VDD VDD VSS VSS gf180mcu_fd_sc_mcu7t5v0__fillcap_8
XFILLER_60_37 VDD VDD VSS VSS gf180mcu_fd_sc_mcu7t5v0__fillcap_8
XFILLER_100_99 VDD VDD VSS VSS gf180mcu_fd_sc_mcu7t5v0__fillcap_4
XTAP_TAPCELL_ROW_10_418 VDD VSS gf180mcu_fd_sc_mcu7t5v0__filltie
XFILLER_5_906 VDD VDD VSS VSS gf180mcu_fd_sc_mcu7t5v0__fillcap_4
XTAP_TAPCELL_ROW_95_1520 VDD VSS gf180mcu_fd_sc_mcu7t5v0__filltie
XFILLER_5_928 VDD VDD VSS VSS gf180mcu_fd_sc_mcu7t5v0__fillcap_4
XFILLER_118_171 VDD VDD VSS VSS gf180mcu_fd_sc_mcu7t5v0__fillcap_4
XFILLER_109_42 VDD VDD VSS VSS gf180mcu_fd_sc_mcu7t5v0__fillcap_8
XFILLER_122_859 VDD VDD VSS VSS gf180mcu_fd_sc_mcu7t5v0__fillcap_16
XFILLER_121_314 VDD VDD VSS VSS gf180mcu_fd_sc_mcu7t5v0__fillcap_16
XFILLER_130_870 VDD VDD VSS VSS gf180mcu_fd_sc_mcu7t5v0__fillcap_4
XFILLER_102_594 VDD VDD VSS VSS gf180mcu_fd_sc_mcu7t5v0__fill_1
XFILLER_47_136 VDD VDD VSS VSS gf180mcu_fd_sc_mcu7t5v0__fillcap_4
XFILLER_91_927 VDD VDD VSS VSS gf180mcu_fd_sc_mcu7t5v0__fillcap_4
XFILLER_28_350 VDD VDD VSS VSS gf180mcu_fd_sc_mcu7t5v0__fill_1
XTAP_TAPCELL_ROW_18_518 VDD VSS gf180mcu_fd_sc_mcu7t5v0__filltie
XFILLER_62_139 VDD VDD VSS VSS gf180mcu_fd_sc_mcu7t5v0__fillcap_16
XFILLER_16_567 VDD VDD VSS VSS gf180mcu_fd_sc_mcu7t5v0__fillcap_16
XPHY_EDGE_ROW_75_Left_208 VDD VSS gf180mcu_fd_sc_mcu7t5v0__endcap
XFILLER_31_548 VDD VDD VSS VSS gf180mcu_fd_sc_mcu7t5v0__fillcap_4
XFILLER_7_276 VDD VDD VSS VSS gf180mcu_fd_sc_mcu7t5v0__fillcap_4
XTAP_TAPCELL_ROW_55_1003 VDD VSS gf180mcu_fd_sc_mcu7t5v0__filltie
XFILLER_125_697 VDD VDD VSS VSS gf180mcu_fd_sc_mcu7t5v0__fill_2
XFILLER_124_174 VDD VDD VSS VSS gf180mcu_fd_sc_mcu7t5v0__fill_1
XPHY_EDGE_ROW_84_Left_217 VDD VSS gf180mcu_fd_sc_mcu7t5v0__endcap
X_3260_ place91/Z _4063_/Q _3260_/Z VDD VDD VSS VSS gf180mcu_fd_sc_mcu7t5v0__xor2_1
XFILLER_39_604 VDD VDD VSS VSS gf180mcu_fd_sc_mcu7t5v0__fillcap_16
X_2211_ _3748_/Q _3756_/Q _3644_/Q _3652_/Q place79/Z place78/Z _2211_/Z VDD VDD VSS
+ VSS gf180mcu_fd_sc_mcu7t5v0__mux4_1
X_2142_ _2142_/A1 _2142_/A2 _2142_/A3 _2142_/ZN VDD VDD VSS VSS gf180mcu_fd_sc_mcu7t5v0__nand3_1
XFILLER_66_445 VDD VDD VSS VSS gf180mcu_fd_sc_mcu7t5v0__fillcap_8
X_2073_ _4142_/Q _2073_/A2 _2074_/A2 VDD VDD VSS VSS gf180mcu_fd_sc_mcu7t5v0__nand2_1
XFILLER_93_253 VDD VDD VSS VSS gf180mcu_fd_sc_mcu7t5v0__fillcap_16
XFILLER_54_629 VDD VDD VSS VSS gf180mcu_fd_sc_mcu7t5v0__fillcap_8
XFILLER_19_372 VDD VDD VSS VSS gf180mcu_fd_sc_mcu7t5v0__fillcap_8
XPHY_EDGE_ROW_93_Left_226 VDD VSS gf180mcu_fd_sc_mcu7t5v0__endcap
XTAP_TAPCELL_ROW_66_1143 VDD VSS gf180mcu_fd_sc_mcu7t5v0__filltie
XTAP_TAPCELL_ROW_45_871 VDD VSS gf180mcu_fd_sc_mcu7t5v0__filltie
XFILLER_50_802 VDD VDD VSS VSS gf180mcu_fd_sc_mcu7t5v0__fill_2
XFILLER_62_662 VDD VDD VSS VSS gf180mcu_fd_sc_mcu7t5v0__fill_2
XTAP_TAPCELL_ROW_118_1818 VDD VSS gf180mcu_fd_sc_mcu7t5v0__filltie
X_1926_ _1923_/B _1919_/C _2013_/A4 _1935_/A4 _1927_/A3 VDD VDD VSS VSS gf180mcu_fd_sc_mcu7t5v0__nand4_1
X_1857_ _3894_/Q _1901_/C _1901_/B _3893_/Q _1858_/B2 VDD VDD VSS VSS gf180mcu_fd_sc_mcu7t5v0__oai211_1
XTAP_TAPCELL_ROW_77_1283 VDD VSS gf180mcu_fd_sc_mcu7t5v0__filltie
XFILLER_2_909 VDD VDD VSS VSS gf180mcu_fd_sc_mcu7t5v0__fillcap_16
XFILLER_131_634 VDD VDD VSS VSS gf180mcu_fd_sc_mcu7t5v0__fill_1
XFILLER_103_314 VDD VDD VSS VSS gf180mcu_fd_sc_mcu7t5v0__fillcap_16
XFILLER_1_419 VDD VDD VSS VSS gf180mcu_fd_sc_mcu7t5v0__fill_1
XFILLER_131_667 VDD VDD VSS VSS gf180mcu_fd_sc_mcu7t5v0__fillcap_4
XTAP_TAPCELL_ROW_90_1461 VDD VSS gf180mcu_fd_sc_mcu7t5v0__filltie
XTAP_TAPCELL_ROW_90_1450 VDD VSS gf180mcu_fd_sc_mcu7t5v0__filltie
X_3458_ _4105_/Q _3471_/A1 VDD VDD VSS VSS gf180mcu_fd_sc_mcu7t5v0__clkinv_1
XFILLER_130_177 VDD VDD VSS VSS gf180mcu_fd_sc_mcu7t5v0__fillcap_16
X_3389_ _3389_/A1 _3382_/B _3390_/A2 VDD VDD VSS VSS gf180mcu_fd_sc_mcu7t5v0__nor2_1
XFILLER_85_710 VDD VDD VSS VSS gf180mcu_fd_sc_mcu7t5v0__fill_2
XTAP_TAPCELL_ROW_129_1969 VDD VSS gf180mcu_fd_sc_mcu7t5v0__filltie
XTAP_TAPCELL_ROW_129_1958 VDD VSS gf180mcu_fd_sc_mcu7t5v0__filltie
XFILLER_85_765 VDD VDD VSS VSS gf180mcu_fd_sc_mcu7t5v0__fillcap_4
XFILLER_45_629 VDD VDD VSS VSS gf180mcu_fd_sc_mcu7t5v0__fill_1
XFILLER_26_843 VDD VDD VSS VSS gf180mcu_fd_sc_mcu7t5v0__fill_2
XFILLER_44_139 VDD VDD VSS VSS gf180mcu_fd_sc_mcu7t5v0__fillcap_16
XFILLER_40_301 VDD VDD VSS VSS gf180mcu_fd_sc_mcu7t5v0__fillcap_8
XPHY_EDGE_ROW_109_Right_109 VDD VSS gf180mcu_fd_sc_mcu7t5v0__endcap
XTAP_TAPCELL_ROW_23_587 VDD VSS gf180mcu_fd_sc_mcu7t5v0__filltie
XFILLER_5_769 VDD VDD VSS VSS gf180mcu_fd_sc_mcu7t5v0__fill_1
XFILLER_122_667 VDD VDD VSS VSS gf180mcu_fd_sc_mcu7t5v0__fillcap_64
XFILLER_122_645 VDD VDD VSS VSS gf180mcu_fd_sc_mcu7t5v0__fillcap_4
XFILLER_110_807 VDD VDD VSS VSS gf180mcu_fd_sc_mcu7t5v0__fillcap_8
XFILLER_76_732 VDD VDD VSS VSS gf180mcu_fd_sc_mcu7t5v0__fill_2
XFILLER_91_702 VDD VDD VSS VSS gf180mcu_fd_sc_mcu7t5v0__fillcap_16
XFILLER_36_607 VDD VDD VSS VSS gf180mcu_fd_sc_mcu7t5v0__fillcap_4
XFILLER_48_489 VDD VDD VSS VSS gf180mcu_fd_sc_mcu7t5v0__fillcap_8
XTAP_TAPCELL_ROW_102_1608 VDD VSS gf180mcu_fd_sc_mcu7t5v0__filltie
XFILLER_44_662 VDD VDD VSS VSS gf180mcu_fd_sc_mcu7t5v0__fill_2
XFILLER_71_492 VDD VDD VSS VSS gf180mcu_fd_sc_mcu7t5v0__fillcap_16
XTAP_TAPCELL_ROW_42_830 VDD VSS gf180mcu_fd_sc_mcu7t5v0__filltie
X_2760_ _3834_/Q place85/Z _2764_/S _3834_/D VDD VDD VSS VSS gf180mcu_fd_sc_mcu7t5v0__mux2_2
XTAP_TAPCELL_ROW_61_1073 VDD VSS gf180mcu_fd_sc_mcu7t5v0__filltie
XTAP_TAPCELL_ROW_61_1084 VDD VSS gf180mcu_fd_sc_mcu7t5v0__filltie
XFILLER_129_266 VDD VDD VSS VSS gf180mcu_fd_sc_mcu7t5v0__fillcap_4
XFILLER_12_592 VDD VDD VSS VSS gf180mcu_fd_sc_mcu7t5v0__fill_2
X_2691_ place84/Z _3803_/Q _2693_/S _3803_/D VDD VDD VSS VSS gf180mcu_fd_sc_mcu7t5v0__mux2_2
XANTENNA_2 _2170_/ZN VDD VDD VSS VSS gf180mcu_fd_sc_mcu7t5v0__antenna
XFILLER_6_53 VDD VDD VSS VSS gf180mcu_fd_sc_mcu7t5v0__fillcap_8
XFILLER_112_100 VDD VDD VSS VSS gf180mcu_fd_sc_mcu7t5v0__fillcap_4
XTAP_TAPCELL_ROW_113_1759 VDD VSS gf180mcu_fd_sc_mcu7t5v0__filltie
XFILLER_3_290 VDD VDD VSS VSS gf180mcu_fd_sc_mcu7t5v0__fill_1
X_3243_ _3249_/B _3243_/A2 _4059_/D VDD VDD VSS VSS gf180mcu_fd_sc_mcu7t5v0__or2_1
XFILLER_112_177 VDD VDD VSS VSS gf180mcu_fd_sc_mcu7t5v0__fillcap_64
XFILLER_100_317 VDD VDD VSS VSS gf180mcu_fd_sc_mcu7t5v0__fill_2
XFILLER_98_389 VDD VDD VSS VSS gf180mcu_fd_sc_mcu7t5v0__fill_1
XFILLER_100_328 VDD VDD VSS VSS gf180mcu_fd_sc_mcu7t5v0__fillcap_32
XFILLER_67_776 VDD VDD VSS VSS gf180mcu_fd_sc_mcu7t5v0__fill_1
XFILLER_81_212 VDD VDD VSS VSS gf180mcu_fd_sc_mcu7t5v0__fillcap_8
X_2125_ _3630_/Q _3686_/Q _3694_/Q _3702_/Q place79/Z place78/Z _2125_/Z VDD VDD VSS
+ VSS gf180mcu_fd_sc_mcu7t5v0__mux4_1
XFILLER_27_629 VDD VDD VSS VSS gf180mcu_fd_sc_mcu7t5v0__fill_1
XFILLER_39_489 VDD VDD VSS VSS gf180mcu_fd_sc_mcu7t5v0__fill_1
XFILLER_54_415 VDD VDD VSS VSS gf180mcu_fd_sc_mcu7t5v0__fill_2
X_2056_ _4139_/Q _4138_/Q _4137_/Q _4136_/Q _2079_/A3 VDD VDD VSS VSS gf180mcu_fd_sc_mcu7t5v0__nand4_1
XFILLER_25_18 VDD VDD VSS VSS gf180mcu_fd_sc_mcu7t5v0__fillcap_8
XFILLER_34_161 VDD VDD VSS VSS gf180mcu_fd_sc_mcu7t5v0__fillcap_8
XTAP_TAPCELL_ROW_124_1899 VDD VSS gf180mcu_fd_sc_mcu7t5v0__filltie
XFILLER_22_312 VDD VDD VSS VSS gf180mcu_fd_sc_mcu7t5v0__fill_2
X_2958_ _4045_/Q _3925_/Q _2972_/S _3925_/D VDD VDD VSS VSS gf180mcu_fd_sc_mcu7t5v0__mux2_2
XFILLER_109_907 VDD VDD VSS VSS gf180mcu_fd_sc_mcu7t5v0__fill_2
X_1909_ _1853_/B _1855_/B _1910_/I0 VDD VDD VSS VSS gf180mcu_fd_sc_mcu7t5v0__nor2_1
XTAP_TAPCELL_ROW_79_1312 VDD VSS gf180mcu_fd_sc_mcu7t5v0__filltie
XTAP_TAPCELL_ROW_20_546 VDD VSS gf180mcu_fd_sc_mcu7t5v0__filltie
X_2889_ _1853_/B _2900_/S _2889_/B _3892_/D VDD VDD VSS VSS gf180mcu_fd_sc_mcu7t5v0__oai21_1
XFILLER_132_932 VDD VDD VSS VSS gf180mcu_fd_sc_mcu7t5v0__fill_2
XFILLER_116_483 VDD VDD VSS VSS gf180mcu_fd_sc_mcu7t5v0__fill_1
XFILLER_89_334 VDD VDD VSS VSS gf180mcu_fd_sc_mcu7t5v0__fill_2
XFILLER_106_43 VDD VDD VSS VSS gf180mcu_fd_sc_mcu7t5v0__fillcap_4
XFILLER_104_667 VDD VDD VSS VSS gf180mcu_fd_sc_mcu7t5v0__fillcap_32
XFILLER_100_840 VDD VDD VSS VSS gf180mcu_fd_sc_mcu7t5v0__fillcap_16
XFILLER_73_702 VDD VDD VSS VSS gf180mcu_fd_sc_mcu7t5v0__fillcap_16
XFILLER_46_927 VDD VDD VSS VSS gf180mcu_fd_sc_mcu7t5v0__fillcap_4
XFILLER_122_31 VDD VDD VSS VSS gf180mcu_fd_sc_mcu7t5v0__fillcap_4
XFILLER_45_404 VDD VDD VSS VSS gf180mcu_fd_sc_mcu7t5v0__fillcap_16
XFILLER_72_201 VDD VDD VSS VSS gf180mcu_fd_sc_mcu7t5v0__fillcap_4
XTAP_TAPCELL_ROW_28_646 VDD VSS gf180mcu_fd_sc_mcu7t5v0__filltie
XTAP_TAPCELL_ROW_0_271 VDD VSS gf180mcu_fd_sc_mcu7t5v0__filltie
XFILLER_26_662 VDD VDD VSS VSS gf180mcu_fd_sc_mcu7t5v0__fill_2
XFILLER_81_790 VDD VDD VSS VSS gf180mcu_fd_sc_mcu7t5v0__fill_1
XTAP_TAPCELL_ROW_0_282 VDD VSS gf180mcu_fd_sc_mcu7t5v0__filltie
XFILLER_41_632 VDD VDD VSS VSS gf180mcu_fd_sc_mcu7t5v0__fillcap_64
XFILLER_53_470 VDD VDD VSS VSS gf180mcu_fd_sc_mcu7t5v0__fill_2
XFILLER_53_492 VDD VDD VSS VSS gf180mcu_fd_sc_mcu7t5v0__fill_1
XFILLER_13_356 VDD VDD VSS VSS gf180mcu_fd_sc_mcu7t5v0__fill_2
XFILLER_9_338 VDD VDD VSS VSS gf180mcu_fd_sc_mcu7t5v0__fillcap_8
XFILLER_126_247 VDD VDD VSS VSS gf180mcu_fd_sc_mcu7t5v0__fillcap_4
XFILLER_5_555 VDD VDD VSS VSS gf180mcu_fd_sc_mcu7t5v0__fillcap_4
XFILLER_31_72 VDD VDD VSS VSS gf180mcu_fd_sc_mcu7t5v0__fillcap_8
XFILLER_123_932 VDD VDD VSS VSS gf180mcu_fd_sc_mcu7t5v0__fill_2
XFILLER_122_453 VDD VDD VSS VSS gf180mcu_fd_sc_mcu7t5v0__fill_2
XTAP_TAPCELL_ROW_8_393 VDD VSS gf180mcu_fd_sc_mcu7t5v0__filltie
XFILLER_37_905 VDD VDD VSS VSS gf180mcu_fd_sc_mcu7t5v0__fillcap_4
XTAP_TAPCELL_ROW_47_900 VDD VSS gf180mcu_fd_sc_mcu7t5v0__filltie
XFILLER_63_212 VDD VDD VSS VSS gf180mcu_fd_sc_mcu7t5v0__fillcap_64
X_3930_ _3930_/D _2279_/I _4128_/CLK _3930_/Q VDD VDD VSS VSS gf180mcu_fd_sc_mcu7t5v0__dffrnq_1
XFILLER_51_418 VDD VDD VSS VSS gf180mcu_fd_sc_mcu7t5v0__fill_2
XTAP_TAPCELL_ROW_63_1102 VDD VSS gf180mcu_fd_sc_mcu7t5v0__filltie
X_3861_ _3861_/D _3866_/CLK _3861_/Q VDD VDD VSS VSS gf180mcu_fd_sc_mcu7t5v0__dffq_1
XFILLER_31_142 VDD VDD VSS VSS gf180mcu_fd_sc_mcu7t5v0__fillcap_64
X_3792_ _3792_/D _4129_/CLK _3792_/Q VDD VDD VSS VSS gf180mcu_fd_sc_mcu7t5v0__dffq_1
X_2812_ place85/Z _3858_/Q _2816_/S _3858_/D VDD VDD VSS VSS gf180mcu_fd_sc_mcu7t5v0__mux2_2
XFILLER_118_737 VDD VDD VSS VSS gf180mcu_fd_sc_mcu7t5v0__fill_1
X_2674_ place84/Z _3795_/Q _2676_/S _3795_/D VDD VDD VSS VSS gf180mcu_fd_sc_mcu7t5v0__mux2_2
XFILLER_132_206 VDD VDD VSS VSS gf180mcu_fd_sc_mcu7t5v0__fillcap_32
XTAP_TAPCELL_ROW_74_1253 VDD VSS gf180mcu_fd_sc_mcu7t5v0__filltie
XTAP_TAPCELL_ROW_74_1242 VDD VSS gf180mcu_fd_sc_mcu7t5v0__filltie
XFILLER_113_475 VDD VDD VSS VSS gf180mcu_fd_sc_mcu7t5v0__fillcap_8
XFILLER_99_698 VDD VDD VSS VSS gf180mcu_fd_sc_mcu7t5v0__fill_2
XFILLER_100_103 VDD VDD VSS VSS gf180mcu_fd_sc_mcu7t5v0__fill_2
XFILLER_100_147 VDD VDD VSS VSS gf180mcu_fd_sc_mcu7t5v0__fill_1
XFILLER_95_860 VDD VDD VSS VSS gf180mcu_fd_sc_mcu7t5v0__fill_1
XFILLER_39_220 VDD VDD VSS VSS gf180mcu_fd_sc_mcu7t5v0__fillcap_4
XFILLER_55_702 VDD VDD VSS VSS gf180mcu_fd_sc_mcu7t5v0__fillcap_64
XTAP_TAPCELL_ROW_126_1928 VDD VSS gf180mcu_fd_sc_mcu7t5v0__filltie
XFILLER_82_521 VDD VDD VSS VSS gf180mcu_fd_sc_mcu7t5v0__fillcap_4
XFILLER_27_415 VDD VDD VSS VSS gf180mcu_fd_sc_mcu7t5v0__fillcap_4
XFILLER_39_264 VDD VDD VSS VSS gf180mcu_fd_sc_mcu7t5v0__fillcap_4
XFILLER_94_381 VDD VDD VSS VSS gf180mcu_fd_sc_mcu7t5v0__fillcap_4
X_2108_ _4110_/Q _3933_/Q _2152_/S _2108_/Z VDD VDD VSS VSS gf180mcu_fd_sc_mcu7t5v0__mux2_2
X_3088_ _3985_/Q _3088_/I1 _4131_/D _3985_/D VDD VDD VSS VSS gf180mcu_fd_sc_mcu7t5v0__mux2_2
XTAP_TAPCELL_ROW_25_605 VDD VSS gf180mcu_fd_sc_mcu7t5v0__filltie
XTAP_TAPCELL_ROW_25_616 VDD VSS gf180mcu_fd_sc_mcu7t5v0__filltie
X_2039_ place52/Z _2039_/A2 _2040_/B VDD VDD VSS VSS gf180mcu_fd_sc_mcu7t5v0__nand2_1
XTAP_TAPCELL_ROW_85_1393 VDD VSS gf180mcu_fd_sc_mcu7t5v0__filltie
XFILLER_23_632 VDD VDD VSS VSS gf180mcu_fd_sc_mcu7t5v0__fillcap_32
XTAP_TAPCELL_ROW_53_969 VDD VSS gf180mcu_fd_sc_mcu7t5v0__filltie
XFILLER_10_337 VDD VDD VSS VSS gf180mcu_fd_sc_mcu7t5v0__fillcap_4
XFILLER_108_247 VDD VDD VSS VSS gf180mcu_fd_sc_mcu7t5v0__fillcap_64
XFILLER_123_228 VDD VDD VSS VSS gf180mcu_fd_sc_mcu7t5v0__fillcap_8
XFILLER_105_932 VDD VDD VSS VSS gf180mcu_fd_sc_mcu7t5v0__fill_2
XFILLER_89_142 VDD VDD VSS VSS gf180mcu_fd_sc_mcu7t5v0__fillcap_8
XFILLER_89_186 VDD VDD VSS VSS gf180mcu_fd_sc_mcu7t5v0__fillcap_16
XFILLER_77_68 VDD VDD VSS VSS gf180mcu_fd_sc_mcu7t5v0__fill_2
XTAP_TAPCELL_ROW_5_352 VDD VSS gf180mcu_fd_sc_mcu7t5v0__filltie
XFILLER_45_212 VDD VDD VSS VSS gf180mcu_fd_sc_mcu7t5v0__fillcap_8
XFILLER_60_215 VDD VDD VSS VSS gf180mcu_fd_sc_mcu7t5v0__fill_1
XFILLER_9_124 VDD VDD VSS VSS gf180mcu_fd_sc_mcu7t5v0__fillcap_16
XFILLER_10_871 VDD VDD VSS VSS gf180mcu_fd_sc_mcu7t5v0__fillcap_4
XTAP_TAPCELL_ROW_110_1718 VDD VSS gf180mcu_fd_sc_mcu7t5v0__filltie
XFILLER_110_423 VDD VDD VSS VSS gf180mcu_fd_sc_mcu7t5v0__fillcap_32
XFILLER_69_838 VDD VDD VSS VSS gf180mcu_fd_sc_mcu7t5v0__fill_2
X_4060_ _4060_/D _2279_/I _4128_/CLK _4060_/Q VDD VDD VSS VSS gf180mcu_fd_sc_mcu7t5v0__dffrnq_1
XFILLER_110_489 VDD VDD VSS VSS gf180mcu_fd_sc_mcu7t5v0__fillcap_8
XFILLER_49_562 VDD VDD VSS VSS gf180mcu_fd_sc_mcu7t5v0__fillcap_16
XFILLER_17_492 VDD VDD VSS VSS gf180mcu_fd_sc_mcu7t5v0__fillcap_64
X_3913_ _3913_/D _4157_/RN _3976_/CLK _3913_/Q VDD VDD VSS VSS gf180mcu_fd_sc_mcu7t5v0__dffrnq_1
XTAP_TAPCELL_ROW_121_1858 VDD VSS gf180mcu_fd_sc_mcu7t5v0__filltie
XFILLER_32_451 VDD VDD VSS VSS gf180mcu_fd_sc_mcu7t5v0__fillcap_4
XFILLER_20_613 VDD VDD VSS VSS gf180mcu_fd_sc_mcu7t5v0__fillcap_8
X_3844_ _3844_/D _4123_/CLK _3844_/Q VDD VDD VSS VSS gf180mcu_fd_sc_mcu7t5v0__dffq_1
XTAP_TAPCELL_ROW_50_939 VDD VSS gf180mcu_fd_sc_mcu7t5v0__filltie
XTAP_TAPCELL_ROW_30_674 VDD VSS gf180mcu_fd_sc_mcu7t5v0__filltie
X_3775_ _3775_/D _3877_/CLK _3775_/Q VDD VDD VSS VSS gf180mcu_fd_sc_mcu7t5v0__dffq_1
X_2726_ _3819_/Q place84/Z _2728_/S _3819_/D VDD VDD VSS VSS gf180mcu_fd_sc_mcu7t5v0__mux2_2
XFILLER_120_209 VDD VDD VSS VSS gf180mcu_fd_sc_mcu7t5v0__fillcap_16
X_2588_ _3759_/Q place88/Z _2598_/S _3759_/D VDD VDD VSS VSS gf180mcu_fd_sc_mcu7t5v0__mux2_2
XTAP_TAPCELL_ROW_132_1998 VDD VSS gf180mcu_fd_sc_mcu7t5v0__filltie
XFILLER_102_924 VDD VDD VSS VSS gf180mcu_fd_sc_mcu7t5v0__fillcap_8
XFILLER_99_484 VDD VDD VSS VSS gf180mcu_fd_sc_mcu7t5v0__fillcap_4
XFILLER_86_101 VDD VDD VSS VSS gf180mcu_fd_sc_mcu7t5v0__fillcap_4
XFILLER_87_679 VDD VDD VSS VSS gf180mcu_fd_sc_mcu7t5v0__fillcap_16
X_3209_ _4043_/Q _4011_/Q _4129_/D _4043_/D VDD VDD VSS VSS gf180mcu_fd_sc_mcu7t5v0__mux2_2
XTAP_TAPCELL_ROW_87_1411 VDD VSS gf180mcu_fd_sc_mcu7t5v0__filltie
XFILLER_86_189 VDD VDD VSS VSS gf180mcu_fd_sc_mcu7t5v0__fillcap_32
XTAP_TAPCELL_ROW_2_311 VDD VSS gf180mcu_fd_sc_mcu7t5v0__filltie
XFILLER_68_893 VDD VDD VSS VSS gf180mcu_fd_sc_mcu7t5v0__fill_2
XTAP_TAPCELL_ROW_87_1422 VDD VSS gf180mcu_fd_sc_mcu7t5v0__filltie
XFILLER_103_66 VDD VDD VSS VSS gf180mcu_fd_sc_mcu7t5v0__fillcap_4
XFILLER_83_874 VDD VDD VSS VSS gf180mcu_fd_sc_mcu7t5v0__fillcap_16
XTAP_TAPCELL_ROW_38_774 VDD VSS gf180mcu_fd_sc_mcu7t5v0__filltie
XFILLER_55_554 VDD VDD VSS VSS gf180mcu_fd_sc_mcu7t5v0__fillcap_4
XFILLER_103_88 VDD VDD VSS VSS gf180mcu_fd_sc_mcu7t5v0__fillcap_8
XFILLER_82_384 VDD VDD VSS VSS gf180mcu_fd_sc_mcu7t5v0__fill_1
XTAP_TAPCELL_ROW_38_785 VDD VSS gf180mcu_fd_sc_mcu7t5v0__filltie
XFILLER_10_101 VDD VDD VSS VSS gf180mcu_fd_sc_mcu7t5v0__fillcap_4
XFILLER_23_484 VDD VDD VSS VSS gf180mcu_fd_sc_mcu7t5v0__fillcap_4
XFILLER_11_657 VDD VDD VSS VSS gf180mcu_fd_sc_mcu7t5v0__fill_2
XFILLER_10_123 VDD VDD VSS VSS gf180mcu_fd_sc_mcu7t5v0__fillcap_8
XFILLER_7_606 VDD VDD VSS VSS gf180mcu_fd_sc_mcu7t5v0__fill_1
XTAP_TAPCELL_ROW_98_1562 VDD VSS gf180mcu_fd_sc_mcu7t5v0__filltie
XFILLER_128_63 VDD VDD VSS VSS gf180mcu_fd_sc_mcu7t5v0__fillcap_8
Xhold190 s_axi_wdata[3] hold190/Z VDD VDD VSS VSS gf180mcu_fd_sc_mcu7t5v0__dlyc_1
XFILLER_104_294 VDD VDD VSS VSS gf180mcu_fd_sc_mcu7t5v0__fillcap_16
XFILLER_19_702 VDD VDD VSS VSS gf180mcu_fd_sc_mcu7t5v0__fillcap_64
XFILLER_46_521 VDD VDD VSS VSS gf180mcu_fd_sc_mcu7t5v0__fillcap_4
XFILLER_73_340 VDD VDD VSS VSS gf180mcu_fd_sc_mcu7t5v0__fill_1
XPHY_EDGE_ROW_16_Right_16 VDD VSS gf180mcu_fd_sc_mcu7t5v0__endcap
XTAP_TAPCELL_ROW_107_1680 VDD VSS gf180mcu_fd_sc_mcu7t5v0__filltie
XFILLER_30_933 VDD VDD VSS VSS gf180mcu_fd_sc_mcu7t5v0__fill_1
X_1890_ _4136_/Q _2041_/A1 VDD VDD VSS VSS gf180mcu_fd_sc_mcu7t5v0__clkinv_1
XFILLER_14_495 VDD VDD VSS VSS gf180mcu_fd_sc_mcu7t5v0__fill_1
XFILLER_128_854 VDD VDD VSS VSS gf180mcu_fd_sc_mcu7t5v0__fillcap_16
X_3560_ _3759_/Q _3815_/Q _3823_/Q _3831_/Q _4116_/Q place75/Z _3560_/Z VDD VDD VSS
+ VSS gf180mcu_fd_sc_mcu7t5v0__mux4_1
XPHY_EDGE_ROW_25_Right_25 VDD VSS gf180mcu_fd_sc_mcu7t5v0__endcap
XTAP_TAPCELL_ROW_58_1034 VDD VSS gf180mcu_fd_sc_mcu7t5v0__filltie
X_2511_ _3727_/Q _4069_/Q _2521_/S _3727_/D VDD VDD VSS VSS gf180mcu_fd_sc_mcu7t5v0__mux2_2
XFILLER_6_683 VDD VDD VSS VSS gf180mcu_fd_sc_mcu7t5v0__fillcap_4
X_3491_ _4149_/Q _4152_/Q _3491_/Z VDD VDD VSS VSS gf180mcu_fd_sc_mcu7t5v0__xor2_1
XTAP_TAPCELL_ROW_58_1045 VDD VSS gf180mcu_fd_sc_mcu7t5v0__filltie
XFILLER_102_209 VDD VDD VSS VSS gf180mcu_fd_sc_mcu7t5v0__fillcap_16
XTAP_TAPCELL_ROW_71_1212 VDD VSS gf180mcu_fd_sc_mcu7t5v0__filltie
X_2442_ _3697_/Q _4071_/Q _2448_/S _3697_/D VDD VDD VSS VSS gf180mcu_fd_sc_mcu7t5v0__mux2_2
XFILLER_69_602 VDD VDD VSS VSS gf180mcu_fd_sc_mcu7t5v0__fillcap_16
XFILLER_111_710 VDD VDD VSS VSS gf180mcu_fd_sc_mcu7t5v0__fill_2
X_2373_ _3666_/Q place80/Z _2377_/S _3666_/D VDD VDD VSS VSS gf180mcu_fd_sc_mcu7t5v0__mux2_2
XFILLER_38_2 VDD VDD VSS VSS gf180mcu_fd_sc_mcu7t5v0__fillcap_4
XFILLER_68_101 VDD VDD VSS VSS gf180mcu_fd_sc_mcu7t5v0__fillcap_4
XFILLER_96_443 VDD VDD VSS VSS gf180mcu_fd_sc_mcu7t5v0__fillcap_8
X_4112_ _4112_/D _2279_/I _4112_/CLK _4112_/Q VDD VDD VSS VSS gf180mcu_fd_sc_mcu7t5v0__dffrnq_1
XFILLER_68_123 VDD VDD VSS VSS gf180mcu_fd_sc_mcu7t5v0__fillcap_4
X_4043_ _4043_/D _4148_/RN _4146_/CLK _4043_/Q VDD VDD VSS VSS gf180mcu_fd_sc_mcu7t5v0__dffrnq_1
XFILLER_111_798 VDD VDD VSS VSS gf180mcu_fd_sc_mcu7t5v0__fill_1
XPHY_EDGE_ROW_34_Right_34 VDD VSS gf180mcu_fd_sc_mcu7t5v0__endcap
XFILLER_37_532 VDD VDD VSS VSS gf180mcu_fd_sc_mcu7t5v0__fillcap_4
XFILLER_52_524 VDD VDD VSS VSS gf180mcu_fd_sc_mcu7t5v0__fill_1
XTAP_TAPCELL_ROW_69_1185 VDD VSS gf180mcu_fd_sc_mcu7t5v0__filltie
XFILLER_80_877 VDD VDD VSS VSS gf180mcu_fd_sc_mcu7t5v0__fillcap_16
XTAP_TAPCELL_ROW_35_744 VDD VSS gf180mcu_fd_sc_mcu7t5v0__filltie
XTAP_TAPCELL_ROW_82_1352 VDD VSS gf180mcu_fd_sc_mcu7t5v0__filltie
X_3827_ _3827_/D _3835_/CLK _3827_/Q VDD VDD VSS VSS gf180mcu_fd_sc_mcu7t5v0__dffq_1
XPHY_EDGE_ROW_43_Right_43 VDD VSS gf180mcu_fd_sc_mcu7t5v0__endcap
XPHY_EDGE_ROW_104_Left_237 VDD VSS gf180mcu_fd_sc_mcu7t5v0__endcap
X_3758_ _3758_/D _4159_/CLK _3758_/Q VDD VDD VSS VSS gf180mcu_fd_sc_mcu7t5v0__dffq_1
X_3689_ _3689_/D _3740_/CLK _3689_/Q VDD VDD VSS VSS gf180mcu_fd_sc_mcu7t5v0__dffq_1
XTAP_TAPCELL_ROW_93_1492 VDD VSS gf180mcu_fd_sc_mcu7t5v0__filltie
XFILLER_88_933 VDD VDD VSS VSS gf180mcu_fd_sc_mcu7t5v0__fill_1
XFILLER_58_37 VDD VDD VSS VSS gf180mcu_fd_sc_mcu7t5v0__fillcap_8
XPHY_EDGE_ROW_113_Left_246 VDD VSS gf180mcu_fd_sc_mcu7t5v0__endcap
XPHY_EDGE_ROW_52_Right_52 VDD VSS gf180mcu_fd_sc_mcu7t5v0__endcap
XFILLER_87_498 VDD VDD VSS VSS gf180mcu_fd_sc_mcu7t5v0__fill_1
XFILLER_59_189 VDD VDD VSS VSS gf180mcu_fd_sc_mcu7t5v0__fillcap_8
XFILLER_28_554 VDD VDD VSS VSS gf180mcu_fd_sc_mcu7t5v0__fillcap_4
XFILLER_56_874 VDD VDD VSS VSS gf180mcu_fd_sc_mcu7t5v0__fill_1
XFILLER_71_833 VDD VDD VSS VSS gf180mcu_fd_sc_mcu7t5v0__fillcap_4
XFILLER_43_524 VDD VDD VSS VSS gf180mcu_fd_sc_mcu7t5v0__fill_1
XFILLER_15_259 VDD VDD VSS VSS gf180mcu_fd_sc_mcu7t5v0__fillcap_16
XFILLER_43_557 VDD VDD VSS VSS gf180mcu_fd_sc_mcu7t5v0__fill_2
XFILLER_70_387 VDD VDD VSS VSS gf180mcu_fd_sc_mcu7t5v0__fillcap_64
XFILLER_90_79 VDD VDD VSS VSS gf180mcu_fd_sc_mcu7t5v0__fillcap_8
XTAP_TAPCELL_ROW_13_449 VDD VSS gf180mcu_fd_sc_mcu7t5v0__filltie
XFILLER_12_933 VDD VDD VSS VSS gf180mcu_fd_sc_mcu7t5v0__fill_1
XPHY_EDGE_ROW_61_Right_61 VDD VSS gf180mcu_fd_sc_mcu7t5v0__endcap
XPHY_EDGE_ROW_122_Left_255 VDD VSS gf180mcu_fd_sc_mcu7t5v0__endcap
XFILLER_99_22 VDD VDD VSS VSS gf180mcu_fd_sc_mcu7t5v0__fill_2
XFILLER_125_846 VDD VDD VSS VSS gf180mcu_fd_sc_mcu7t5v0__fill_2
XFILLER_99_66 VDD VDD VSS VSS gf180mcu_fd_sc_mcu7t5v0__fillcap_4
XFILLER_112_507 VDD VDD VSS VSS gf180mcu_fd_sc_mcu7t5v0__fill_2
XFILLER_98_719 VDD VDD VSS VSS gf180mcu_fd_sc_mcu7t5v0__fillcap_16
XFILLER_97_207 VDD VDD VSS VSS gf180mcu_fd_sc_mcu7t5v0__fill_2
XFILLER_3_675 VDD VDD VSS VSS gf180mcu_fd_sc_mcu7t5v0__fillcap_8
XPHY_EDGE_ROW_70_Right_70 VDD VSS gf180mcu_fd_sc_mcu7t5v0__endcap
XPHY_EDGE_ROW_131_Left_264 VDD VSS gf180mcu_fd_sc_mcu7t5v0__endcap
XFILLER_93_402 VDD VDD VSS VSS gf180mcu_fd_sc_mcu7t5v0__fill_1
XFILLER_65_104 VDD VDD VSS VSS gf180mcu_fd_sc_mcu7t5v0__fillcap_4
XFILLER_19_532 VDD VDD VSS VSS gf180mcu_fd_sc_mcu7t5v0__fillcap_4
XFILLER_65_137 VDD VDD VSS VSS gf180mcu_fd_sc_mcu7t5v0__fill_2
XFILLER_80_107 VDD VDD VSS VSS gf180mcu_fd_sc_mcu7t5v0__fillcap_32
XFILLER_74_693 VDD VDD VSS VSS gf180mcu_fd_sc_mcu7t5v0__fillcap_32
XFILLER_34_524 VDD VDD VSS VSS gf180mcu_fd_sc_mcu7t5v0__fill_1
XFILLER_34_535 VDD VDD VSS VSS gf180mcu_fd_sc_mcu7t5v0__fillcap_4
XFILLER_46_362 VDD VDD VSS VSS gf180mcu_fd_sc_mcu7t5v0__fillcap_16
XFILLER_46_384 VDD VDD VSS VSS gf180mcu_fd_sc_mcu7t5v0__fill_1
XFILLER_62_844 VDD VDD VSS VSS gf180mcu_fd_sc_mcu7t5v0__fillcap_16
XFILLER_73_192 VDD VDD VSS VSS gf180mcu_fd_sc_mcu7t5v0__fillcap_16
X_2991_ _3940_/Q place83/Z _3041_/S _3940_/D VDD VDD VSS VSS gf180mcu_fd_sc_mcu7t5v0__mux2_2
XTAP_TAPCELL_ROW_32_703 VDD VSS gf180mcu_fd_sc_mcu7t5v0__filltie
X_1942_ _2903_/A1 _4146_/Q _1942_/B _1943_/C VDD VDD VSS VSS gf180mcu_fd_sc_mcu7t5v0__oai21_1
X_1873_ _3887_/Q _1873_/A2 _1873_/B1 _1881_/A2 _1873_/C _1884_/A2 VDD VDD VSS VSS
+ gf180mcu_fd_sc_mcu7t5v0__aoi221_1
X_3612_ _3627_/I1 _4162_/Q _3612_/S _4162_/D VDD VDD VSS VSS gf180mcu_fd_sc_mcu7t5v0__mux2_2
XFILLER_128_673 VDD VDD VSS VSS gf180mcu_fd_sc_mcu7t5v0__fill_1
X_3543_ _4123_/Q _3543_/A2 _4123_/D VDD VDD VSS VSS gf180mcu_fd_sc_mcu7t5v0__xnor2_1
X_3474_ _3474_/A1 _3474_/A2 _4107_/Q _3475_/B VDD VDD VSS VSS gf180mcu_fd_sc_mcu7t5v0__oai21_1
XFILLER_97_763 VDD VDD VSS VSS gf180mcu_fd_sc_mcu7t5v0__fill_1
XFILLER_111_562 VDD VDD VSS VSS gf180mcu_fd_sc_mcu7t5v0__fillcap_64
XFILLER_96_273 VDD VDD VSS VSS gf180mcu_fd_sc_mcu7t5v0__fill_1
XFILLER_28_18 VDD VDD VSS VSS gf180mcu_fd_sc_mcu7t5v0__fill_2
XFILLER_84_468 VDD VDD VSS VSS gf180mcu_fd_sc_mcu7t5v0__fill_1
XFILLER_84_457 VDD VDD VSS VSS gf180mcu_fd_sc_mcu7t5v0__fillcap_4
X_4026_ _4026_/D input92/Z _4028_/CLK _4026_/Q VDD VDD VSS VSS gf180mcu_fd_sc_mcu7t5v0__dffrnq_1
XFILLER_38_874 VDD VDD VSS VSS gf180mcu_fd_sc_mcu7t5v0__fill_1
XFILLER_37_384 VDD VDD VSS VSS gf180mcu_fd_sc_mcu7t5v0__fillcap_8
XFILLER_64_170 VDD VDD VSS VSS gf180mcu_fd_sc_mcu7t5v0__fillcap_4
XFILLER_40_527 VDD VDD VSS VSS gf180mcu_fd_sc_mcu7t5v0__fillcap_32
XFILLER_20_251 VDD VDD VSS VSS gf180mcu_fd_sc_mcu7t5v0__fill_2
XFILLER_60_27 VDD VDD VSS VSS gf180mcu_fd_sc_mcu7t5v0__fillcap_8
XTAP_TAPCELL_ROW_10_419 VDD VSS gf180mcu_fd_sc_mcu7t5v0__filltie
XFILLER_20_273 VDD VDD VSS VSS gf180mcu_fd_sc_mcu7t5v0__fill_2
XFILLER_21_796 VDD VDD VSS VSS gf180mcu_fd_sc_mcu7t5v0__fill_2
XFILLER_60_49 VDD VDD VSS VSS gf180mcu_fd_sc_mcu7t5v0__fill_1
XFILLER_107_813 VDD VDD VSS VSS gf180mcu_fd_sc_mcu7t5v0__fillcap_16
XTAP_TAPCELL_ROW_95_1521 VDD VSS gf180mcu_fd_sc_mcu7t5v0__filltie
Xclkbuf_3_0__f_clk clkbuf_0_clk/Z clkbuf_leaf_5_clk/I VDD VDD VSS VSS gf180mcu_fd_sc_mcu7t5v0__clkbuf_16
XFILLER_79_207 VDD VDD VSS VSS gf180mcu_fd_sc_mcu7t5v0__fill_2
XFILLER_69_69 VDD VDD VSS VSS gf180mcu_fd_sc_mcu7t5v0__fill_1
XFILLER_0_656 VDD VDD VSS VSS gf180mcu_fd_sc_mcu7t5v0__fill_2
XFILLER_125_64 VDD VDD VSS VSS gf180mcu_fd_sc_mcu7t5v0__fillcap_4
XFILLER_88_785 VDD VDD VSS VSS gf180mcu_fd_sc_mcu7t5v0__fillcap_8
XFILLER_91_906 VDD VDD VSS VSS gf180mcu_fd_sc_mcu7t5v0__fillcap_4
XTAP_TAPCELL_ROW_18_519 VDD VSS gf180mcu_fd_sc_mcu7t5v0__filltie
XFILLER_62_107 VDD VDD VSS VSS gf180mcu_fd_sc_mcu7t5v0__fillcap_32
XFILLER_16_557 VDD VDD VSS VSS gf180mcu_fd_sc_mcu7t5v0__fillcap_4
XFILLER_28_395 VDD VDD VSS VSS gf180mcu_fd_sc_mcu7t5v0__fill_2
XFILLER_43_332 VDD VDD VSS VSS gf180mcu_fd_sc_mcu7t5v0__fillcap_4
XFILLER_44_877 VDD VDD VSS VSS gf180mcu_fd_sc_mcu7t5v0__fillcap_16
XFILLER_71_696 VDD VDD VSS VSS gf180mcu_fd_sc_mcu7t5v0__fillcap_4
XFILLER_129_404 VDD VDD VSS VSS gf180mcu_fd_sc_mcu7t5v0__fill_1
XFILLER_125_632 VDD VDD VSS VSS gf180mcu_fd_sc_mcu7t5v0__fillcap_16
XFILLER_109_183 VDD VDD VSS VSS gf180mcu_fd_sc_mcu7t5v0__fillcap_8
XTAP_TAPCELL_ROW_55_1004 VDD VSS gf180mcu_fd_sc_mcu7t5v0__filltie
XFILLER_113_838 VDD VDD VSS VSS gf180mcu_fd_sc_mcu7t5v0__fill_2
XFILLER_98_527 VDD VDD VSS VSS gf180mcu_fd_sc_mcu7t5v0__fillcap_8
XFILLER_112_337 VDD VDD VSS VSS gf180mcu_fd_sc_mcu7t5v0__fill_2
X_2210_ _3716_/Q _3724_/Q _3732_/Q _3740_/Q place79/Z place78/Z _2210_/Z VDD VDD VSS
+ VSS gf180mcu_fd_sc_mcu7t5v0__mux4_1
X_3190_ _4034_/Q _4002_/Q _4129_/D _4034_/D VDD VDD VSS VSS gf180mcu_fd_sc_mcu7t5v0__mux2_2
XFILLER_93_221 VDD VDD VSS VSS gf180mcu_fd_sc_mcu7t5v0__fillcap_32
X_2141_ _3902_/Q place72/Z place68/Z _3886_/Q _2141_/C _2142_/A3 VDD VDD VSS VSS gf180mcu_fd_sc_mcu7t5v0__aoi221_1
X_2072_ _2008_/Z _2072_/A2 _2072_/B _4142_/D VDD VDD VSS VSS gf180mcu_fd_sc_mcu7t5v0__oai21_4
XFILLER_66_457 VDD VDD VSS VSS gf180mcu_fd_sc_mcu7t5v0__fillcap_8
XFILLER_93_298 VDD VDD VSS VSS gf180mcu_fd_sc_mcu7t5v0__fill_2
XFILLER_81_416 VDD VDD VSS VSS gf180mcu_fd_sc_mcu7t5v0__fillcap_4
XFILLER_19_384 VDD VDD VSS VSS gf180mcu_fd_sc_mcu7t5v0__fill_2
XFILLER_35_866 VDD VDD VSS VSS gf180mcu_fd_sc_mcu7t5v0__fillcap_4
XFILLER_46_192 VDD VDD VSS VSS gf180mcu_fd_sc_mcu7t5v0__fillcap_16
XTAP_TAPCELL_ROW_66_1144 VDD VSS gf180mcu_fd_sc_mcu7t5v0__filltie
XFILLER_35_899 VDD VDD VSS VSS gf180mcu_fd_sc_mcu7t5v0__fillcap_8
XTAP_TAPCELL_ROW_45_872 VDD VSS gf180mcu_fd_sc_mcu7t5v0__filltie
X_2974_ _4055_/Q _3519_/A1 _4057_/Q _3519_/A2 _2974_/Z VDD VDD VSS VSS gf180mcu_fd_sc_mcu7t5v0__and4_1
XFILLER_22_527 VDD VDD VSS VSS gf180mcu_fd_sc_mcu7t5v0__fillcap_16
XFILLER_34_387 VDD VDD VSS VSS gf180mcu_fd_sc_mcu7t5v0__fillcap_16
X_1925_ _1905_/Z _1820_/Z _1822_/Z _4142_/Q _1927_/A2 VDD VDD VSS VSS gf180mcu_fd_sc_mcu7t5v0__oai31_1
XTAP_TAPCELL_ROW_118_1819 VDD VSS gf180mcu_fd_sc_mcu7t5v0__filltie
X_1856_ _3894_/Q _1901_/C _1858_/B1 VDD VDD VSS VSS gf180mcu_fd_sc_mcu7t5v0__nand2_1
XFILLER_115_142 VDD VDD VSS VSS gf180mcu_fd_sc_mcu7t5v0__fillcap_16
X_3526_ place75/Z _3526_/A2 _4117_/D VDD VDD VSS VSS gf180mcu_fd_sc_mcu7t5v0__xnor2_1
XFILLER_130_101 VDD VDD VSS VSS gf180mcu_fd_sc_mcu7t5v0__fillcap_4
XTAP_TAPCELL_ROW_77_1284 VDD VSS gf180mcu_fd_sc_mcu7t5v0__filltie
XFILLER_1_409 VDD VDD VSS VSS gf180mcu_fd_sc_mcu7t5v0__fillcap_8
XTAP_TAPCELL_ROW_90_1451 VDD VSS gf180mcu_fd_sc_mcu7t5v0__filltie
X_3457_ _3457_/A1 _3457_/A2 _3495_/B _4104_/D VDD VDD VSS VSS gf180mcu_fd_sc_mcu7t5v0__aoi21_2
XFILLER_112_871 VDD VDD VSS VSS gf180mcu_fd_sc_mcu7t5v0__fillcap_4
XFILLER_97_571 VDD VDD VSS VSS gf180mcu_fd_sc_mcu7t5v0__fill_1
XTAP_TAPCELL_ROW_90_1462 VDD VSS gf180mcu_fd_sc_mcu7t5v0__filltie
X_2408_ place80/Z _3682_/Q _2412_/S _3682_/D VDD VDD VSS VSS gf180mcu_fd_sc_mcu7t5v0__mux2_2
XFILLER_58_925 VDD VDD VSS VSS gf180mcu_fd_sc_mcu7t5v0__fillcap_8
XTAP_TAPCELL_ROW_129_1959 VDD VSS gf180mcu_fd_sc_mcu7t5v0__filltie
XFILLER_84_243 VDD VDD VSS VSS gf180mcu_fd_sc_mcu7t5v0__fill_2
XFILLER_73_928 VDD VDD VSS VSS gf180mcu_fd_sc_mcu7t5v0__fillcap_4
XFILLER_73_906 VDD VDD VSS VSS gf180mcu_fd_sc_mcu7t5v0__fillcap_4
XPHY_EDGE_ROW_2_Right_2 VDD VSS gf180mcu_fd_sc_mcu7t5v0__endcap
XFILLER_45_619 VDD VDD VSS VSS gf180mcu_fd_sc_mcu7t5v0__fillcap_8
X_4009_ _4009_/D input92/Z _4045_/CLK _4009_/Q VDD VDD VSS VSS gf180mcu_fd_sc_mcu7t5v0__dffrnq_1
XFILLER_84_287 VDD VDD VSS VSS gf180mcu_fd_sc_mcu7t5v0__fillcap_16
XFILLER_44_107 VDD VDD VSS VSS gf180mcu_fd_sc_mcu7t5v0__fillcap_32
XFILLER_26_877 VDD VDD VSS VSS gf180mcu_fd_sc_mcu7t5v0__fillcap_16
XFILLER_52_140 VDD VDD VSS VSS gf180mcu_fd_sc_mcu7t5v0__fillcap_4
XFILLER_53_663 VDD VDD VSS VSS gf180mcu_fd_sc_mcu7t5v0__fill_1
XFILLER_40_313 VDD VDD VSS VSS gf180mcu_fd_sc_mcu7t5v0__fill_2
XFILLER_41_836 VDD VDD VSS VSS gf180mcu_fd_sc_mcu7t5v0__fillcap_4
XFILLER_41_858 VDD VDD VSS VSS gf180mcu_fd_sc_mcu7t5v0__fillcap_4
XFILLER_52_195 VDD VDD VSS VSS gf180mcu_fd_sc_mcu7t5v0__fill_1
XFILLER_53_696 VDD VDD VSS VSS gf180mcu_fd_sc_mcu7t5v0__fillcap_4
XFILLER_71_48 VDD VDD VSS VSS gf180mcu_fd_sc_mcu7t5v0__fill_1
XTAP_TAPCELL_ROW_23_588 VDD VSS gf180mcu_fd_sc_mcu7t5v0__filltie
XFILLER_107_632 VDD VDD VSS VSS gf180mcu_fd_sc_mcu7t5v0__fillcap_16
XFILLER_119_492 VDD VDD VSS VSS gf180mcu_fd_sc_mcu7t5v0__fillcap_32
XFILLER_107_654 VDD VDD VSS VSS gf180mcu_fd_sc_mcu7t5v0__fillcap_4
XFILLER_105_2 VDD VDD VSS VSS gf180mcu_fd_sc_mcu7t5v0__fillcap_8
XFILLER_4_247 VDD VDD VSS VSS gf180mcu_fd_sc_mcu7t5v0__fillcap_16
XFILLER_20_41 VDD VDD VSS VSS gf180mcu_fd_sc_mcu7t5v0__fill_2
XFILLER_107_698 VDD VDD VSS VSS gf180mcu_fd_sc_mcu7t5v0__fill_2
XFILLER_121_134 VDD VDD VSS VSS gf180mcu_fd_sc_mcu7t5v0__fillcap_4
XFILLER_1_932 VDD VDD VSS VSS gf180mcu_fd_sc_mcu7t5v0__fill_2
XFILLER_110_819 VDD VDD VSS VSS gf180mcu_fd_sc_mcu7t5v0__fill_2
XFILLER_96_45 VDD VDD VSS VSS gf180mcu_fd_sc_mcu7t5v0__fillcap_4
XFILLER_102_381 VDD VDD VSS VSS gf180mcu_fd_sc_mcu7t5v0__fillcap_4
XFILLER_29_72 VDD VDD VSS VSS gf180mcu_fd_sc_mcu7t5v0__fillcap_16
XFILLER_48_457 VDD VDD VSS VSS gf180mcu_fd_sc_mcu7t5v0__fillcap_32
XFILLER_75_298 VDD VDD VSS VSS gf180mcu_fd_sc_mcu7t5v0__fillcap_4
Xclkbuf_leaf_55_clk clkbuf_leaf_5_clk/I _3864_/CLK VDD VDD VSS VSS gf180mcu_fd_sc_mcu7t5v0__clkbuf_8
XFILLER_63_438 VDD VDD VSS VSS gf180mcu_fd_sc_mcu7t5v0__fillcap_8
XTAP_TAPCELL_ROW_102_1609 VDD VSS gf180mcu_fd_sc_mcu7t5v0__filltie
XFILLER_90_279 VDD VDD VSS VSS gf180mcu_fd_sc_mcu7t5v0__fillcap_8
XFILLER_16_387 VDD VDD VSS VSS gf180mcu_fd_sc_mcu7t5v0__fillcap_64
XTAP_TAPCELL_ROW_42_831 VDD VSS gf180mcu_fd_sc_mcu7t5v0__filltie
XFILLER_129_212 VDD VDD VSS VSS gf180mcu_fd_sc_mcu7t5v0__fillcap_16
XTAP_TAPCELL_ROW_61_1074 VDD VSS gf180mcu_fd_sc_mcu7t5v0__filltie
XTAP_TAPCELL_ROW_61_1085 VDD VSS gf180mcu_fd_sc_mcu7t5v0__filltie
XANTENNA_3 _2187_/ZN VDD VDD VSS VSS gf180mcu_fd_sc_mcu7t5v0__antenna
XFILLER_8_597 VDD VDD VSS VSS gf180mcu_fd_sc_mcu7t5v0__fillcap_64
XFILLER_6_65 VDD VDD VSS VSS gf180mcu_fd_sc_mcu7t5v0__fill_2
XTAP_TAPCELL_ROW_113_1749 VDD VSS gf180mcu_fd_sc_mcu7t5v0__filltie
X_3311_ _4074_/Q _4160_/Q _4157_/D _4074_/D VDD VDD VSS VSS gf180mcu_fd_sc_mcu7t5v0__mux2_2
XFILLER_99_858 VDD VDD VSS VSS gf180mcu_fd_sc_mcu7t5v0__fillcap_8
XFILLER_98_357 VDD VDD VSS VSS gf180mcu_fd_sc_mcu7t5v0__fill_2
X_3242_ _3242_/A1 _3242_/A2 _3243_/A2 VDD VDD VSS VSS gf180mcu_fd_sc_mcu7t5v0__nor2_1
X_3173_ place85/Z _3994_/Q _4129_/D _4026_/D VDD VDD VSS VSS gf180mcu_fd_sc_mcu7t5v0__mux2_2
XFILLER_20_2 VDD VDD VSS VSS gf180mcu_fd_sc_mcu7t5v0__fillcap_4
X_2124_ _2124_/A1 _2124_/A2 _2124_/ZN VDD VDD VSS VSS gf180mcu_fd_sc_mcu7t5v0__nand2_1
XFILLER_55_906 VDD VDD VSS VSS gf180mcu_fd_sc_mcu7t5v0__fillcap_4
XFILLER_67_766 VDD VDD VSS VSS gf180mcu_fd_sc_mcu7t5v0__fillcap_4
XFILLER_26_107 VDD VDD VSS VSS gf180mcu_fd_sc_mcu7t5v0__fillcap_4
XFILLER_39_479 VDD VDD VSS VSS gf180mcu_fd_sc_mcu7t5v0__fillcap_8
XFILLER_55_928 VDD VDD VSS VSS gf180mcu_fd_sc_mcu7t5v0__fillcap_4
X_2055_ _2008_/Z _2055_/A2 _2055_/B _4139_/D VDD VDD VSS VSS gf180mcu_fd_sc_mcu7t5v0__oai21_4
Xclkbuf_leaf_46_clk clkload3/I _4159_/CLK VDD VDD VSS VSS gf180mcu_fd_sc_mcu7t5v0__clkbuf_8
XFILLER_23_858 VDD VDD VSS VSS gf180mcu_fd_sc_mcu7t5v0__fillcap_4
XFILLER_34_173 VDD VDD VSS VSS gf180mcu_fd_sc_mcu7t5v0__fill_2
X_1908_ _1908_/A1 _1908_/A2 _1908_/B _1915_/B VDD VDD VSS VSS gf180mcu_fd_sc_mcu7t5v0__oai21_1
X_2888_ place83/Z _2900_/S _2889_/B VDD VDD VSS VSS gf180mcu_fd_sc_mcu7t5v0__nand2_1
XTAP_TAPCELL_ROW_79_1313 VDD VSS gf180mcu_fd_sc_mcu7t5v0__filltie
XTAP_TAPCELL_ROW_20_547 VDD VSS gf180mcu_fd_sc_mcu7t5v0__filltie
X_1839_ _1827_/Z _1839_/A2 _1842_/A3 VDD VDD VSS VSS gf180mcu_fd_sc_mcu7t5v0__nand2_1
XFILLER_116_473 VDD VDD VSS VSS gf180mcu_fd_sc_mcu7t5v0__fillcap_8
X_3509_ _3506_/Z _3501_/Z _3509_/B1 _3516_/A2 _3510_/A2 VDD VDD VSS VSS gf180mcu_fd_sc_mcu7t5v0__oai22_1
XFILLER_131_454 VDD VDD VSS VSS gf180mcu_fd_sc_mcu7t5v0__fillcap_8
XFILLER_77_508 VDD VDD VSS VSS gf180mcu_fd_sc_mcu7t5v0__fillcap_8
XFILLER_131_487 VDD VDD VSS VSS gf180mcu_fd_sc_mcu7t5v0__fill_2
XFILLER_85_541 VDD VDD VSS VSS gf180mcu_fd_sc_mcu7t5v0__fill_2
XFILLER_85_574 VDD VDD VSS VSS gf180mcu_fd_sc_mcu7t5v0__fill_1
XFILLER_57_276 VDD VDD VSS VSS gf180mcu_fd_sc_mcu7t5v0__fillcap_4
XFILLER_73_769 VDD VDD VSS VSS gf180mcu_fd_sc_mcu7t5v0__fill_1
XTAP_TAPCELL_ROW_28_647 VDD VSS gf180mcu_fd_sc_mcu7t5v0__filltie
Xclkbuf_leaf_37_clk clkload4/I _3755_/CLK VDD VDD VSS VSS gf180mcu_fd_sc_mcu7t5v0__clkbuf_8
XFILLER_14_803 VDD VDD VSS VSS gf180mcu_fd_sc_mcu7t5v0__fill_2
XTAP_TAPCELL_ROW_0_272 VDD VSS gf180mcu_fd_sc_mcu7t5v0__filltie
XFILLER_81_780 VDD VDD VSS VSS gf180mcu_fd_sc_mcu7t5v0__fill_2
XTAP_TAPCELL_ROW_0_283 VDD VSS gf180mcu_fd_sc_mcu7t5v0__filltie
XFILLER_13_346 VDD VDD VSS VSS gf180mcu_fd_sc_mcu7t5v0__fillcap_4
XFILLER_31_84 VDD VDD VSS VSS gf180mcu_fd_sc_mcu7t5v0__fill_1
XFILLER_122_432 VDD VDD VSS VSS gf180mcu_fd_sc_mcu7t5v0__fill_1
XTAP_TAPCELL_ROW_8_394 VDD VSS gf180mcu_fd_sc_mcu7t5v0__filltie
XFILLER_95_349 VDD VDD VSS VSS gf180mcu_fd_sc_mcu7t5v0__fill_1
Xinput140 hold222/Z _3115_/I1 VDD VDD VSS VSS gf180mcu_fd_sc_mcu7t5v0__dlyb_1
XFILLER_49_766 VDD VDD VSS VSS gf180mcu_fd_sc_mcu7t5v0__fillcap_4
XFILLER_37_928 VDD VDD VSS VSS gf180mcu_fd_sc_mcu7t5v0__fillcap_4
XTAP_TAPCELL_ROW_47_901 VDD VSS gf180mcu_fd_sc_mcu7t5v0__filltie
Xclkbuf_leaf_28_clk clkload6/I _3968_/CLK VDD VDD VSS VSS gf180mcu_fd_sc_mcu7t5v0__clkbuf_8
XFILLER_17_696 VDD VDD VSS VSS gf180mcu_fd_sc_mcu7t5v0__fillcap_4
XTAP_TAPCELL_ROW_63_1103 VDD VSS gf180mcu_fd_sc_mcu7t5v0__filltie
X_3860_ _3860_/D clkload8/I _3860_/Q VDD VDD VSS VSS gf180mcu_fd_sc_mcu7t5v0__dffq_1
X_3791_ _3791_/D _3864_/CLK _3791_/Q VDD VDD VSS VSS gf180mcu_fd_sc_mcu7t5v0__dffq_1
X_2742_ _3826_/Q place85/Z _2746_/S _3826_/D VDD VDD VSS VSS gf180mcu_fd_sc_mcu7t5v0__mux2_2
XFILLER_114_933 VDD VDD VSS VSS gf180mcu_fd_sc_mcu7t5v0__fill_1
XPHY_EDGE_ROW_99_Right_99 VDD VSS gf180mcu_fd_sc_mcu7t5v0__endcap
XFILLER_99_655 VDD VDD VSS VSS gf180mcu_fd_sc_mcu7t5v0__fillcap_4
XTAP_TAPCELL_ROW_74_1254 VDD VSS gf180mcu_fd_sc_mcu7t5v0__filltie
XTAP_TAPCELL_ROW_74_1243 VDD VSS gf180mcu_fd_sc_mcu7t5v0__filltie
XFILLER_113_443 VDD VDD VSS VSS gf180mcu_fd_sc_mcu7t5v0__fillcap_32
X_3225_ _4051_/Q _4019_/Q _4129_/D _4051_/D VDD VDD VSS VSS gf180mcu_fd_sc_mcu7t5v0__mux2_2
XFILLER_113_487 VDD VDD VSS VSS gf180mcu_fd_sc_mcu7t5v0__fill_2
XTAP_TAPCELL_ROW_126_1929 VDD VSS gf180mcu_fd_sc_mcu7t5v0__filltie
XTAP_TAPCELL_ROW_126_1918 VDD VSS gf180mcu_fd_sc_mcu7t5v0__filltie
X_3156_ _4018_/Q _3156_/I1 _3160_/S _4018_/D VDD VDD VSS VSS gf180mcu_fd_sc_mcu7t5v0__mux2_2
XFILLER_36_18 VDD VDD VSS VSS gf180mcu_fd_sc_mcu7t5v0__fill_2
X_2107_ _3375_/A2 _2106_/Z _2124_/A1 VDD VDD VSS VSS gf180mcu_fd_sc_mcu7t5v0__nand2_1
Xclkbuf_leaf_19_clk clkload2/I _4127_/CLK VDD VDD VSS VSS gf180mcu_fd_sc_mcu7t5v0__clkbuf_8
XFILLER_27_449 VDD VDD VSS VSS gf180mcu_fd_sc_mcu7t5v0__fillcap_32
XFILLER_39_298 VDD VDD VSS VSS gf180mcu_fd_sc_mcu7t5v0__fillcap_32
X_2038_ _2097_/A2 _2097_/A3 _2039_/A2 _2040_/A2 VDD VDD VSS VSS gf180mcu_fd_sc_mcu7t5v0__nand3_2
XFILLER_82_577 VDD VDD VSS VSS gf180mcu_fd_sc_mcu7t5v0__fill_1
XTAP_TAPCELL_ROW_25_606 VDD VSS gf180mcu_fd_sc_mcu7t5v0__filltie
XTAP_TAPCELL_ROW_25_617 VDD VSS gf180mcu_fd_sc_mcu7t5v0__filltie
XTAP_TAPCELL_ROW_85_1394 VDD VSS gf180mcu_fd_sc_mcu7t5v0__filltie
XFILLER_22_143 VDD VDD VSS VSS gf180mcu_fd_sc_mcu7t5v0__fill_2
XFILLER_62_290 VDD VDD VSS VSS gf180mcu_fd_sc_mcu7t5v0__fillcap_16
X_3989_ _3989_/D input92/Z _4023_/CLK _3989_/Q VDD VDD VSS VSS gf180mcu_fd_sc_mcu7t5v0__dffrnq_1
XFILLER_117_54 VDD VDD VSS VSS gf180mcu_fd_sc_mcu7t5v0__fill_1
XFILLER_104_465 VDD VDD VSS VSS gf180mcu_fd_sc_mcu7t5v0__fillcap_4
XFILLER_78_839 VDD VDD VSS VSS gf180mcu_fd_sc_mcu7t5v0__fillcap_8
XTAP_TAPCELL_ROW_5_353 VDD VSS gf180mcu_fd_sc_mcu7t5v0__filltie
XFILLER_19_906 VDD VDD VSS VSS gf180mcu_fd_sc_mcu7t5v0__fillcap_4
XFILLER_19_928 VDD VDD VSS VSS gf180mcu_fd_sc_mcu7t5v0__fillcap_4
XFILLER_45_202 VDD VDD VSS VSS gf180mcu_fd_sc_mcu7t5v0__fillcap_8
XFILLER_46_725 VDD VDD VSS VSS gf180mcu_fd_sc_mcu7t5v0__fillcap_8
XFILLER_45_279 VDD VDD VSS VSS gf180mcu_fd_sc_mcu7t5v0__fill_1
XFILLER_54_791 VDD VDD VSS VSS gf180mcu_fd_sc_mcu7t5v0__fillcap_8
XFILLER_13_165 VDD VDD VSS VSS gf180mcu_fd_sc_mcu7t5v0__fill_2
XFILLER_42_61 VDD VDD VSS VSS gf180mcu_fd_sc_mcu7t5v0__fillcap_4
XFILLER_127_557 VDD VDD VSS VSS gf180mcu_fd_sc_mcu7t5v0__fill_2
XFILLER_5_320 VDD VDD VSS VSS gf180mcu_fd_sc_mcu7t5v0__fill_1
XFILLER_6_865 VDD VDD VSS VSS gf180mcu_fd_sc_mcu7t5v0__fillcap_8
XFILLER_123_730 VDD VDD VSS VSS gf180mcu_fd_sc_mcu7t5v0__fill_1
XFILLER_5_397 VDD VDD VSS VSS gf180mcu_fd_sc_mcu7t5v0__fillcap_4
XTAP_TAPCELL_ROW_110_1719 VDD VSS gf180mcu_fd_sc_mcu7t5v0__filltie
XFILLER_110_402 VDD VDD VSS VSS gf180mcu_fd_sc_mcu7t5v0__fill_2
XFILLER_110_457 VDD VDD VSS VSS gf180mcu_fd_sc_mcu7t5v0__fillcap_32
XFILLER_95_135 VDD VDD VSS VSS gf180mcu_fd_sc_mcu7t5v0__fillcap_4
XFILLER_95_146 VDD VDD VSS VSS gf180mcu_fd_sc_mcu7t5v0__fill_1
XFILLER_68_349 VDD VDD VSS VSS gf180mcu_fd_sc_mcu7t5v0__fillcap_4
X_3010_ _3949_/Q _4037_/Q _3041_/S _3949_/D VDD VDD VSS VSS gf180mcu_fd_sc_mcu7t5v0__mux2_2
XFILLER_77_894 VDD VDD VSS VSS gf180mcu_fd_sc_mcu7t5v0__fill_1
XFILLER_49_552 VDD VDD VSS VSS gf180mcu_fd_sc_mcu7t5v0__fillcap_8
XFILLER_91_330 VDD VDD VSS VSS gf180mcu_fd_sc_mcu7t5v0__fillcap_4
XFILLER_37_769 VDD VDD VSS VSS gf180mcu_fd_sc_mcu7t5v0__fill_1
XFILLER_52_728 VDD VDD VSS VSS gf180mcu_fd_sc_mcu7t5v0__fillcap_4
XTAP_TAPCELL_ROW_121_1859 VDD VSS gf180mcu_fd_sc_mcu7t5v0__filltie
X_3912_ _3912_/D _4157_/RN _3976_/CLK _3912_/Q VDD VDD VSS VSS gf180mcu_fd_sc_mcu7t5v0__dffrnq_1
XPHY_EDGE_ROW_17_Left_150 VDD VSS gf180mcu_fd_sc_mcu7t5v0__endcap
X_3843_ _3843_/D _3866_/CLK _3843_/Q VDD VDD VSS VSS gf180mcu_fd_sc_mcu7t5v0__dffq_1
XFILLER_118_513 VDD VDD VSS VSS gf180mcu_fd_sc_mcu7t5v0__fillcap_8
X_3774_ _3774_/D _4023_/CLK _3774_/Q VDD VDD VSS VSS gf180mcu_fd_sc_mcu7t5v0__dffq_1
XFILLER_118_535 VDD VDD VSS VSS gf180mcu_fd_sc_mcu7t5v0__fill_1
XTAP_TAPCELL_ROW_30_675 VDD VSS gf180mcu_fd_sc_mcu7t5v0__filltie
Xclkbuf_leaf_8_clk clkload2/I _4138_/CLK VDD VDD VSS VSS gf180mcu_fd_sc_mcu7t5v0__clkbuf_8
X_2656_ place84/Z _3787_/Q _2658_/S _3787_/D VDD VDD VSS VSS gf180mcu_fd_sc_mcu7t5v0__mux2_2
XTAP_TAPCELL_ROW_132_1999 VDD VSS gf180mcu_fd_sc_mcu7t5v0__filltie
XFILLER_113_262 VDD VDD VSS VSS gf180mcu_fd_sc_mcu7t5v0__fillcap_4
XFILLER_101_424 VDD VDD VSS VSS gf180mcu_fd_sc_mcu7t5v0__fill_1
XFILLER_87_647 VDD VDD VSS VSS gf180mcu_fd_sc_mcu7t5v0__fillcap_32
XFILLER_59_349 VDD VDD VSS VSS gf180mcu_fd_sc_mcu7t5v0__fill_1
XFILLER_86_157 VDD VDD VSS VSS gf180mcu_fd_sc_mcu7t5v0__fillcap_16
XFILLER_74_319 VDD VDD VSS VSS gf180mcu_fd_sc_mcu7t5v0__fill_1
XTAP_TAPCELL_ROW_2_312 VDD VSS gf180mcu_fd_sc_mcu7t5v0__filltie
XTAP_TAPCELL_ROW_87_1423 VDD VSS gf180mcu_fd_sc_mcu7t5v0__filltie
XTAP_TAPCELL_ROW_87_1412 VDD VSS gf180mcu_fd_sc_mcu7t5v0__filltie
XFILLER_83_842 VDD VDD VSS VSS gf180mcu_fd_sc_mcu7t5v0__fillcap_32
XFILLER_82_341 VDD VDD VSS VSS gf180mcu_fd_sc_mcu7t5v0__fill_2
XFILLER_55_577 VDD VDD VSS VSS gf180mcu_fd_sc_mcu7t5v0__fill_2
XFILLER_55_566 VDD VDD VSS VSS gf180mcu_fd_sc_mcu7t5v0__fill_2
XFILLER_27_279 VDD VDD VSS VSS gf180mcu_fd_sc_mcu7t5v0__fill_1
XFILLER_36_791 VDD VDD VSS VSS gf180mcu_fd_sc_mcu7t5v0__fill_2
XTAP_TAPCELL_ROW_38_775 VDD VSS gf180mcu_fd_sc_mcu7t5v0__filltie
XTAP_TAPCELL_ROW_38_786 VDD VSS gf180mcu_fd_sc_mcu7t5v0__filltie
XFILLER_23_430 VDD VDD VSS VSS gf180mcu_fd_sc_mcu7t5v0__fillcap_4
XFILLER_23_452 VDD VDD VSS VSS gf180mcu_fd_sc_mcu7t5v0__fillcap_32
XFILLER_51_772 VDD VDD VSS VSS gf180mcu_fd_sc_mcu7t5v0__fillcap_8
XFILLER_7_618 VDD VDD VSS VSS gf180mcu_fd_sc_mcu7t5v0__fillcap_8
XTAP_TAPCELL_ROW_98_1563 VDD VSS gf180mcu_fd_sc_mcu7t5v0__filltie
XFILLER_124_527 VDD VDD VSS VSS gf180mcu_fd_sc_mcu7t5v0__fillcap_64
XFILLER_105_752 VDD VDD VSS VSS gf180mcu_fd_sc_mcu7t5v0__fill_2
Xhold191 s_axi_wdata[2] hold191/Z VDD VDD VSS VSS gf180mcu_fd_sc_mcu7t5v0__dlyc_1
XFILLER_73_352 VDD VDD VSS VSS gf180mcu_fd_sc_mcu7t5v0__fillcap_64
XTAP_TAPCELL_ROW_107_1681 VDD VSS gf180mcu_fd_sc_mcu7t5v0__filltie
XFILLER_14_452 VDD VDD VSS VSS gf180mcu_fd_sc_mcu7t5v0__fill_2
XFILLER_41_282 VDD VDD VSS VSS gf180mcu_fd_sc_mcu7t5v0__fillcap_64
XFILLER_128_877 VDD VDD VSS VSS gf180mcu_fd_sc_mcu7t5v0__fillcap_16
XFILLER_6_662 VDD VDD VSS VSS gf180mcu_fd_sc_mcu7t5v0__fill_2
X_3490_ _3907_/Q _4150_/Q _3490_/A3 _3490_/Z VDD VDD VSS VSS gf180mcu_fd_sc_mcu7t5v0__xor3_1
XFILLER_5_150 VDD VDD VSS VSS gf180mcu_fd_sc_mcu7t5v0__fill_1
XTAP_TAPCELL_ROW_58_1035 VDD VSS gf180mcu_fd_sc_mcu7t5v0__filltie
XTAP_TAPCELL_ROW_58_1046 VDD VSS gf180mcu_fd_sc_mcu7t5v0__filltie
XFILLER_97_912 VDD VDD VSS VSS gf180mcu_fd_sc_mcu7t5v0__fillcap_16
XTAP_TAPCELL_ROW_71_1213 VDD VSS gf180mcu_fd_sc_mcu7t5v0__filltie
X_4111_ _4111_/D _4157_/RN _4115_/CLK _4111_/Q VDD VDD VSS VSS gf180mcu_fd_sc_mcu7t5v0__dffrnq_1
XFILLER_69_647 VDD VDD VSS VSS gf180mcu_fd_sc_mcu7t5v0__fill_1
X_4042_ _4042_/D input92/Z _4130_/CLK _4042_/Q VDD VDD VSS VSS gf180mcu_fd_sc_mcu7t5v0__dffrnq_1
XFILLER_111_788 VDD VDD VSS VSS gf180mcu_fd_sc_mcu7t5v0__fillcap_8
XFILLER_110_243 VDD VDD VSS VSS gf180mcu_fd_sc_mcu7t5v0__fill_2
XFILLER_68_157 VDD VDD VSS VSS gf180mcu_fd_sc_mcu7t5v0__fillcap_16
XFILLER_65_842 VDD VDD VSS VSS gf180mcu_fd_sc_mcu7t5v0__fillcap_64
XFILLER_80_801 VDD VDD VSS VSS gf180mcu_fd_sc_mcu7t5v0__fillcap_4
XFILLER_80_823 VDD VDD VSS VSS gf180mcu_fd_sc_mcu7t5v0__fill_2
XFILLER_37_588 VDD VDD VSS VSS gf180mcu_fd_sc_mcu7t5v0__fillcap_4
XFILLER_37_599 VDD VDD VSS VSS gf180mcu_fd_sc_mcu7t5v0__fillcap_8
XTAP_TAPCELL_ROW_69_1186 VDD VSS gf180mcu_fd_sc_mcu7t5v0__filltie
XFILLER_91_182 VDD VDD VSS VSS gf180mcu_fd_sc_mcu7t5v0__fillcap_16
XFILLER_80_867 VDD VDD VSS VSS gf180mcu_fd_sc_mcu7t5v0__fillcap_8
XTAP_TAPCELL_ROW_35_745 VDD VSS gf180mcu_fd_sc_mcu7t5v0__filltie
XTAP_TAPCELL_ROW_82_1353 VDD VSS gf180mcu_fd_sc_mcu7t5v0__filltie
XFILLER_21_912 VDD VDD VSS VSS gf180mcu_fd_sc_mcu7t5v0__fillcap_16
XFILLER_33_772 VDD VDD VSS VSS gf180mcu_fd_sc_mcu7t5v0__fillcap_64
XTAP_TAPCELL_ROW_15_480 VDD VSS gf180mcu_fd_sc_mcu7t5v0__filltie
X_3826_ _3826_/D _4153_/CLK _3826_/Q VDD VDD VSS VSS gf180mcu_fd_sc_mcu7t5v0__dffq_1
X_3757_ _3757_/D _4153_/CLK _3757_/Q VDD VDD VSS VSS gf180mcu_fd_sc_mcu7t5v0__dffq_1
X_2708_ place84/Z _3811_/Q _2710_/S _3811_/D VDD VDD VSS VSS gf180mcu_fd_sc_mcu7t5v0__mux2_2
XFILLER_118_387 VDD VDD VSS VSS gf180mcu_fd_sc_mcu7t5v0__fillcap_16
XFILLER_106_527 VDD VDD VSS VSS gf180mcu_fd_sc_mcu7t5v0__fillcap_8
X_3688_ _3688_/D _3738_/CLK _3688_/Q VDD VDD VSS VSS gf180mcu_fd_sc_mcu7t5v0__dffq_1
XTAP_TAPCELL_ROW_93_1493 VDD VSS gf180mcu_fd_sc_mcu7t5v0__filltie
XFILLER_101_232 VDD VDD VSS VSS gf180mcu_fd_sc_mcu7t5v0__fill_2
XFILLER_99_282 VDD VDD VSS VSS gf180mcu_fd_sc_mcu7t5v0__fillcap_8
XFILLER_87_422 VDD VDD VSS VSS gf180mcu_fd_sc_mcu7t5v0__fillcap_8
XFILLER_75_617 VDD VDD VSS VSS gf180mcu_fd_sc_mcu7t5v0__fillcap_8
XFILLER_28_511 VDD VDD VSS VSS gf180mcu_fd_sc_mcu7t5v0__fillcap_8
XFILLER_74_48 VDD VDD VSS VSS gf180mcu_fd_sc_mcu7t5v0__fill_1
XFILLER_74_37 VDD VDD VSS VSS gf180mcu_fd_sc_mcu7t5v0__fill_2
XFILLER_55_352 VDD VDD VSS VSS gf180mcu_fd_sc_mcu7t5v0__fillcap_64
XFILLER_71_812 VDD VDD VSS VSS gf180mcu_fd_sc_mcu7t5v0__fillcap_4
XFILLER_28_588 VDD VDD VSS VSS gf180mcu_fd_sc_mcu7t5v0__fillcap_4
XFILLER_70_311 VDD VDD VSS VSS gf180mcu_fd_sc_mcu7t5v0__fillcap_4
XFILLER_130_32 VDD VDD VSS VSS gf180mcu_fd_sc_mcu7t5v0__fill_2
XFILLER_15_227 VDD VDD VSS VSS gf180mcu_fd_sc_mcu7t5v0__fillcap_32
XFILLER_129_608 VDD VDD VSS VSS gf180mcu_fd_sc_mcu7t5v0__fillcap_16
XFILLER_11_422 VDD VDD VSS VSS gf180mcu_fd_sc_mcu7t5v0__fillcap_8
XFILLER_23_282 VDD VDD VSS VSS gf180mcu_fd_sc_mcu7t5v0__fillcap_64
XFILLER_24_783 VDD VDD VSS VSS gf180mcu_fd_sc_mcu7t5v0__fillcap_16
XFILLER_128_107 VDD VDD VSS VSS gf180mcu_fd_sc_mcu7t5v0__fillcap_4
XFILLER_109_321 VDD VDD VSS VSS gf180mcu_fd_sc_mcu7t5v0__fillcap_16
XFILLER_23_96 VDD VDD VSS VSS gf180mcu_fd_sc_mcu7t5v0__fill_1
XFILLER_125_825 VDD VDD VSS VSS gf180mcu_fd_sc_mcu7t5v0__fillcap_8
XFILLER_124_302 VDD VDD VSS VSS gf180mcu_fd_sc_mcu7t5v0__fillcap_8
XFILLER_109_376 VDD VDD VSS VSS gf180mcu_fd_sc_mcu7t5v0__fillcap_4
XFILLER_3_610 VDD VDD VSS VSS gf180mcu_fd_sc_mcu7t5v0__fillcap_4
XFILLER_124_379 VDD VDD VSS VSS gf180mcu_fd_sc_mcu7t5v0__fill_1
XFILLER_79_912 VDD VDD VSS VSS gf180mcu_fd_sc_mcu7t5v0__fillcap_16
XFILLER_3_698 VDD VDD VSS VSS gf180mcu_fd_sc_mcu7t5v0__fill_2
XFILLER_74_661 VDD VDD VSS VSS gf180mcu_fd_sc_mcu7t5v0__fillcap_4
XFILLER_19_544 VDD VDD VSS VSS gf180mcu_fd_sc_mcu7t5v0__fillcap_16
XFILLER_62_801 VDD VDD VSS VSS gf180mcu_fd_sc_mcu7t5v0__fillcap_4
XFILLER_15_772 VDD VDD VSS VSS gf180mcu_fd_sc_mcu7t5v0__fillcap_8
XTAP_TAPCELL_ROW_32_704 VDD VSS gf180mcu_fd_sc_mcu7t5v0__filltie
X_1941_ _2899_/A1 _1948_/C _4144_/Q _1943_/B1 VDD VDD VSS VSS gf180mcu_fd_sc_mcu7t5v0__oai21_1
XFILLER_9_54 VDD VDD VSS VSS gf180mcu_fd_sc_mcu7t5v0__fillcap_16
X_1872_ _2881_/A1 _4135_/Q _1872_/A3 _1873_/C VDD VDD VSS VSS gf180mcu_fd_sc_mcu7t5v0__nor3_1
X_3611_ _3626_/A1 _3626_/A2 _3623_/A3 _3612_/S VDD VDD VSS VSS gf180mcu_fd_sc_mcu7t5v0__nand3_1
X_3542_ _4122_/Q _2578_/Z _3542_/A3 _3543_/A2 VDD VDD VSS VSS gf180mcu_fd_sc_mcu7t5v0__nand3_1
XFILLER_50_2 VDD VDD VSS VSS gf180mcu_fd_sc_mcu7t5v0__fillcap_32
X_3473_ _3417_/Z _3464_/Z _3474_/A2 VDD VDD VSS VSS gf180mcu_fd_sc_mcu7t5v0__nor2_1
XFILLER_131_839 VDD VDD VSS VSS gf180mcu_fd_sc_mcu7t5v0__fill_1
X_2424_ _3689_/Q _4071_/Q _2430_/S _3689_/D VDD VDD VSS VSS gf180mcu_fd_sc_mcu7t5v0__mux2_2
XFILLER_130_349 VDD VDD VSS VSS gf180mcu_fd_sc_mcu7t5v0__fill_2
X_2355_ _3659_/Q _4073_/Q _2357_/S _3659_/D VDD VDD VSS VSS gf180mcu_fd_sc_mcu7t5v0__mux2_2
XFILLER_69_422 VDD VDD VSS VSS gf180mcu_fd_sc_mcu7t5v0__fillcap_16
XFILLER_96_263 VDD VDD VSS VSS gf180mcu_fd_sc_mcu7t5v0__fillcap_8
X_2286_ _3630_/Q _4068_/Q _2298_/S _3630_/D VDD VDD VSS VSS gf180mcu_fd_sc_mcu7t5v0__mux2_2
X_4025_ _4025_/D _4148_/RN _4057_/CLK _4025_/Q VDD VDD VSS VSS gf180mcu_fd_sc_mcu7t5v0__dffrnq_1
XFILLER_37_352 VDD VDD VSS VSS gf180mcu_fd_sc_mcu7t5v0__fillcap_32
XFILLER_53_834 VDD VDD VSS VSS gf180mcu_fd_sc_mcu7t5v0__fillcap_4
XFILLER_53_856 VDD VDD VSS VSS gf180mcu_fd_sc_mcu7t5v0__fill_1
X_3809_ _3809_/D clkload7/I _3809_/Q VDD VDD VSS VSS gf180mcu_fd_sc_mcu7t5v0__dffq_1
XTAP_TAPCELL_ROW_95_1522 VDD VSS gf180mcu_fd_sc_mcu7t5v0__filltie
XFILLER_119_696 VDD VDD VSS VSS gf180mcu_fd_sc_mcu7t5v0__fillcap_4
XFILLER_109_88 VDD VDD VSS VSS gf180mcu_fd_sc_mcu7t5v0__fillcap_8
XFILLER_125_10 VDD VDD VSS VSS gf180mcu_fd_sc_mcu7t5v0__fillcap_4
XFILLER_122_839 VDD VDD VSS VSS gf180mcu_fd_sc_mcu7t5v0__fillcap_4
XFILLER_121_338 VDD VDD VSS VSS gf180mcu_fd_sc_mcu7t5v0__fillcap_4
XFILLER_88_731 VDD VDD VSS VSS gf180mcu_fd_sc_mcu7t5v0__fillcap_4
XFILLER_102_563 VDD VDD VSS VSS gf180mcu_fd_sc_mcu7t5v0__fillcap_16
XFILLER_0_679 VDD VDD VSS VSS gf180mcu_fd_sc_mcu7t5v0__fill_1
XFILLER_85_69 VDD VDD VSS VSS gf180mcu_fd_sc_mcu7t5v0__fill_1
XFILLER_29_842 VDD VDD VSS VSS gf180mcu_fd_sc_mcu7t5v0__fillcap_64
XFILLER_44_801 VDD VDD VSS VSS gf180mcu_fd_sc_mcu7t5v0__fillcap_4
XFILLER_56_661 VDD VDD VSS VSS gf180mcu_fd_sc_mcu7t5v0__fillcap_4
XFILLER_43_322 VDD VDD VSS VSS gf180mcu_fd_sc_mcu7t5v0__fillcap_4
XTAP_TAPCELL_ROW_104_1640 VDD VSS gf180mcu_fd_sc_mcu7t5v0__filltie
XFILLER_24_580 VDD VDD VSS VSS gf180mcu_fd_sc_mcu7t5v0__fillcap_8
XFILLER_7_212 VDD VDD VSS VSS gf180mcu_fd_sc_mcu7t5v0__fillcap_64
XFILLER_113_806 VDD VDD VSS VSS gf180mcu_fd_sc_mcu7t5v0__fillcap_32
XFILLER_109_195 VDD VDD VSS VSS gf180mcu_fd_sc_mcu7t5v0__fill_2
XTAP_TAPCELL_ROW_55_1005 VDD VSS gf180mcu_fd_sc_mcu7t5v0__filltie
XFILLER_125_699 VDD VDD VSS VSS gf180mcu_fd_sc_mcu7t5v0__fill_1
XTAP_TAPCELL_ROW_115_1780 VDD VSS gf180mcu_fd_sc_mcu7t5v0__filltie
XFILLER_105_390 VDD VDD VSS VSS gf180mcu_fd_sc_mcu7t5v0__fillcap_16
XFILLER_66_403 VDD VDD VSS VSS gf180mcu_fd_sc_mcu7t5v0__fillcap_8
XFILLER_121_894 VDD VDD VSS VSS gf180mcu_fd_sc_mcu7t5v0__fill_1
X_2140_ _2181_/A3 _2140_/A2 _2141_/C VDD VDD VSS VSS gf180mcu_fd_sc_mcu7t5v0__nor2_1
XFILLER_39_628 VDD VDD VSS VSS gf180mcu_fd_sc_mcu7t5v0__fill_2
X_2071_ place71/Z place52/Z _2069_/Z _2072_/B VDD VDD VSS VSS gf180mcu_fd_sc_mcu7t5v0__nand3_1
XFILLER_82_918 VDD VDD VSS VSS gf180mcu_fd_sc_mcu7t5v0__fillcap_16
XFILLER_19_352 VDD VDD VSS VSS gf180mcu_fd_sc_mcu7t5v0__fillcap_4
XTAP_TAPCELL_ROW_66_1145 VDD VSS gf180mcu_fd_sc_mcu7t5v0__filltie
XTAP_TAPCELL_ROW_45_873 VDD VSS gf180mcu_fd_sc_mcu7t5v0__filltie
XFILLER_50_804 VDD VDD VSS VSS gf180mcu_fd_sc_mcu7t5v0__fill_1
XFILLER_62_664 VDD VDD VSS VSS gf180mcu_fd_sc_mcu7t5v0__fill_1
X_1924_ _2895_/A1 _1947_/B _1924_/Z VDD VDD VSS VSS gf180mcu_fd_sc_mcu7t5v0__and2_1
XFILLER_30_550 VDD VDD VSS VSS gf180mcu_fd_sc_mcu7t5v0__fillcap_4
XFILLER_30_583 VDD VDD VSS VSS gf180mcu_fd_sc_mcu7t5v0__fillcap_8
X_1855_ _1919_/B _1855_/A2 _1855_/B _1858_/A2 VDD VDD VSS VSS gf180mcu_fd_sc_mcu7t5v0__oai21_1
X_3525_ place76/Z _3500_/I _3526_/A2 VDD VDD VSS VSS gf180mcu_fd_sc_mcu7t5v0__nand2_1
XFILLER_131_603 VDD VDD VSS VSS gf180mcu_fd_sc_mcu7t5v0__fillcap_16
XPHY_EDGE_ROW_123_Right_123 VDD VSS gf180mcu_fd_sc_mcu7t5v0__endcap
XTAP_TAPCELL_ROW_77_1285 VDD VSS gf180mcu_fd_sc_mcu7t5v0__filltie
XFILLER_115_198 VDD VDD VSS VSS gf180mcu_fd_sc_mcu7t5v0__fillcap_8
XFILLER_103_349 VDD VDD VSS VSS gf180mcu_fd_sc_mcu7t5v0__fill_1
XTAP_TAPCELL_ROW_90_1452 VDD VSS gf180mcu_fd_sc_mcu7t5v0__filltie
XFILLER_39_18 VDD VDD VSS VSS gf180mcu_fd_sc_mcu7t5v0__fill_2
X_3456_ _3435_/C _3456_/A2 _3457_/A2 VDD VDD VSS VSS gf180mcu_fd_sc_mcu7t5v0__nand2_1
X_3387_ _4088_/Q _3387_/A2 _4088_/D VDD VDD VSS VSS gf180mcu_fd_sc_mcu7t5v0__xor2_1
XFILLER_85_712 VDD VDD VSS VSS gf180mcu_fd_sc_mcu7t5v0__fill_1
X_2338_ _4074_/Q _3652_/Q _2338_/S _3652_/D VDD VDD VSS VSS gf180mcu_fd_sc_mcu7t5v0__mux2_2
X_2269_ _2269_/I _2269_/ZN VDD VDD VSS VSS gf180mcu_fd_sc_mcu7t5v0__inv_1
XFILLER_84_233 VDD VDD VSS VSS gf180mcu_fd_sc_mcu7t5v0__fill_2
XFILLER_29_138 VDD VDD VSS VSS gf180mcu_fd_sc_mcu7t5v0__fill_2
X_4008_ _4008_/D input92/Z _4045_/CLK _4008_/Q VDD VDD VSS VSS gf180mcu_fd_sc_mcu7t5v0__dffrnq_1
XFILLER_26_801 VDD VDD VSS VSS gf180mcu_fd_sc_mcu7t5v0__fillcap_4
XFILLER_38_661 VDD VDD VSS VSS gf180mcu_fd_sc_mcu7t5v0__fillcap_4
XFILLER_26_845 VDD VDD VSS VSS gf180mcu_fd_sc_mcu7t5v0__fill_1
XFILLER_111_56 VDD VDD VSS VSS gf180mcu_fd_sc_mcu7t5v0__fillcap_8
XFILLER_80_450 VDD VDD VSS VSS gf180mcu_fd_sc_mcu7t5v0__fillcap_4
XPHY_EDGE_ROW_9_Left_142 VDD VSS gf180mcu_fd_sc_mcu7t5v0__endcap
XTAP_TAPCELL_ROW_23_589 VDD VSS gf180mcu_fd_sc_mcu7t5v0__filltie
XFILLER_0_410 VDD VDD VSS VSS gf180mcu_fd_sc_mcu7t5v0__fillcap_32
XFILLER_76_745 VDD VDD VSS VSS gf180mcu_fd_sc_mcu7t5v0__fillcap_4
XFILLER_76_734 VDD VDD VSS VSS gf180mcu_fd_sc_mcu7t5v0__fill_1
XFILLER_29_40 VDD VDD VSS VSS gf180mcu_fd_sc_mcu7t5v0__fill_1
XFILLER_48_403 VDD VDD VSS VSS gf180mcu_fd_sc_mcu7t5v0__fillcap_8
XFILLER_102_393 VDD VDD VSS VSS gf180mcu_fd_sc_mcu7t5v0__fillcap_16
XFILLER_48_447 VDD VDD VSS VSS gf180mcu_fd_sc_mcu7t5v0__fillcap_8
XFILLER_90_247 VDD VDD VSS VSS gf180mcu_fd_sc_mcu7t5v0__fillcap_32
XFILLER_16_311 VDD VDD VSS VSS gf180mcu_fd_sc_mcu7t5v0__fillcap_4
XFILLER_29_694 VDD VDD VSS VSS gf180mcu_fd_sc_mcu7t5v0__fillcap_4
XFILLER_45_72 VDD VDD VSS VSS gf180mcu_fd_sc_mcu7t5v0__fillcap_64
XFILLER_44_664 VDD VDD VSS VSS gf180mcu_fd_sc_mcu7t5v0__fill_1
XTAP_TAPCELL_ROW_42_832 VDD VSS gf180mcu_fd_sc_mcu7t5v0__filltie
XFILLER_8_521 VDD VDD VSS VSS gf180mcu_fd_sc_mcu7t5v0__fillcap_4
XTAP_TAPCELL_ROW_61_1075 VDD VSS gf180mcu_fd_sc_mcu7t5v0__filltie
XFILLER_12_594 VDD VDD VSS VSS gf180mcu_fd_sc_mcu7t5v0__fill_1
XFILLER_40_892 VDD VDD VSS VSS gf180mcu_fd_sc_mcu7t5v0__fill_2
XANTENNA_4 _2217_/ZN VDD VDD VSS VSS gf180mcu_fd_sc_mcu7t5v0__antenna
XFILLER_125_474 VDD VDD VSS VSS gf180mcu_fd_sc_mcu7t5v0__fill_1
XFILLER_98_303 VDD VDD VSS VSS gf180mcu_fd_sc_mcu7t5v0__fillcap_8
X_3241_ _4059_/Q _3242_/A1 VDD VDD VSS VSS gf180mcu_fd_sc_mcu7t5v0__clkinv_1
X_2123_ _2108_/Z _2177_/A2 _2167_/A2 _2123_/B2 _2123_/C _2124_/A2 VDD VDD VSS VSS
+ gf180mcu_fd_sc_mcu7t5v0__aoi221_1
XFILLER_13_2 VDD VDD VSS VSS gf180mcu_fd_sc_mcu7t5v0__fill_2
XFILLER_94_597 VDD VDD VSS VSS gf180mcu_fd_sc_mcu7t5v0__fillcap_32
XFILLER_82_737 VDD VDD VSS VSS gf180mcu_fd_sc_mcu7t5v0__fillcap_16
X_2054_ place71/Z place52/Z _2052_/Z _2055_/B VDD VDD VSS VSS gf180mcu_fd_sc_mcu7t5v0__nand3_1
XFILLER_62_450 VDD VDD VSS VSS gf180mcu_fd_sc_mcu7t5v0__fillcap_4
XFILLER_22_314 VDD VDD VSS VSS gf180mcu_fd_sc_mcu7t5v0__fill_1
XFILLER_50_667 VDD VDD VSS VSS gf180mcu_fd_sc_mcu7t5v0__fillcap_64
X_2956_ _4044_/Q _3924_/Q _2972_/S _3924_/D VDD VDD VSS VSS gf180mcu_fd_sc_mcu7t5v0__mux2_2
XFILLER_109_909 VDD VDD VSS VSS gf180mcu_fd_sc_mcu7t5v0__fill_1
X_1907_ _1901_/C _2058_/A1 _1901_/B _1907_/B2 _1907_/C _1908_/B VDD VDD VSS VSS gf180mcu_fd_sc_mcu7t5v0__aoi221_1
X_2887_ _2887_/A1 _2900_/S _2887_/B _3891_/D VDD VDD VSS VSS gf180mcu_fd_sc_mcu7t5v0__oai21_1
XTAP_TAPCELL_ROW_79_1314 VDD VSS gf180mcu_fd_sc_mcu7t5v0__filltie
XTAP_TAPCELL_ROW_20_548 VDD VSS gf180mcu_fd_sc_mcu7t5v0__filltie
XFILLER_129_780 VDD VDD VSS VSS gf180mcu_fd_sc_mcu7t5v0__fill_2
X_1838_ _3898_/Q _4145_/Q _1839_/A2 VDD VDD VSS VSS gf180mcu_fd_sc_mcu7t5v0__nor2_1
XFILLER_117_931 VDD VDD VSS VSS gf180mcu_fd_sc_mcu7t5v0__fill_2
XFILLER_108_419 VDD VDD VSS VSS gf180mcu_fd_sc_mcu7t5v0__fillcap_32
XFILLER_131_422 VDD VDD VSS VSS gf180mcu_fd_sc_mcu7t5v0__fillcap_32
XFILLER_89_314 VDD VDD VSS VSS gf180mcu_fd_sc_mcu7t5v0__fillcap_16
X_3508_ _2578_/Z _3508_/A2 _3516_/A2 VDD VDD VSS VSS gf180mcu_fd_sc_mcu7t5v0__nand2_1
XFILLER_131_466 VDD VDD VSS VSS gf180mcu_fd_sc_mcu7t5v0__fill_1
X_3439_ _3444_/A1 _3443_/B _3442_/A3 VDD VDD VSS VSS gf180mcu_fd_sc_mcu7t5v0__nor2_1
XFILLER_97_391 VDD VDD VSS VSS gf180mcu_fd_sc_mcu7t5v0__fillcap_4
XFILLER_73_726 VDD VDD VSS VSS gf180mcu_fd_sc_mcu7t5v0__fill_2
XFILLER_73_759 VDD VDD VSS VSS gf180mcu_fd_sc_mcu7t5v0__fillcap_8
XTAP_TAPCELL_ROW_28_648 VDD VSS gf180mcu_fd_sc_mcu7t5v0__filltie
XFILLER_72_236 VDD VDD VSS VSS gf180mcu_fd_sc_mcu7t5v0__fillcap_8
XFILLER_14_815 VDD VDD VSS VSS gf180mcu_fd_sc_mcu7t5v0__fill_2
XFILLER_25_130 VDD VDD VSS VSS gf180mcu_fd_sc_mcu7t5v0__fillcap_8
XFILLER_26_642 VDD VDD VSS VSS gf180mcu_fd_sc_mcu7t5v0__fillcap_16
XFILLER_26_664 VDD VDD VSS VSS gf180mcu_fd_sc_mcu7t5v0__fill_1
XFILLER_72_247 VDD VDD VSS VSS gf180mcu_fd_sc_mcu7t5v0__fillcap_4
XTAP_TAPCELL_ROW_0_273 VDD VSS gf180mcu_fd_sc_mcu7t5v0__filltie
XTAP_TAPCELL_ROW_0_284 VDD VSS gf180mcu_fd_sc_mcu7t5v0__filltie
XFILLER_40_177 VDD VDD VSS VSS gf180mcu_fd_sc_mcu7t5v0__fillcap_16
XFILLER_127_706 VDD VDD VSS VSS gf180mcu_fd_sc_mcu7t5v0__fill_1
XFILLER_108_931 VDD VDD VSS VSS gf180mcu_fd_sc_mcu7t5v0__fill_2
XFILLER_123_912 VDD VDD VSS VSS gf180mcu_fd_sc_mcu7t5v0__fillcap_16
XFILLER_122_422 VDD VDD VSS VSS gf180mcu_fd_sc_mcu7t5v0__fillcap_8
XFILLER_96_807 VDD VDD VSS VSS gf180mcu_fd_sc_mcu7t5v0__fillcap_64
XTAP_TAPCELL_ROW_8_395 VDD VSS gf180mcu_fd_sc_mcu7t5v0__filltie
XTAP_TAPCELL_ROW_8_384 VDD VSS gf180mcu_fd_sc_mcu7t5v0__filltie
XFILLER_0_240 VDD VDD VSS VSS gf180mcu_fd_sc_mcu7t5v0__fillcap_32
Xinput141 hold189/Z _1972_/A1 VDD VDD VSS VSS gf180mcu_fd_sc_mcu7t5v0__dlyb_1
Xinput130 hold217/Z _3156_/I1 VDD VDD VSS VSS gf180mcu_fd_sc_mcu7t5v0__dlyb_1
XTAP_TAPCELL_ROW_47_902 VDD VSS gf180mcu_fd_sc_mcu7t5v0__filltie
XFILLER_76_597 VDD VDD VSS VSS gf180mcu_fd_sc_mcu7t5v0__fillcap_16
XFILLER_64_737 VDD VDD VSS VSS gf180mcu_fd_sc_mcu7t5v0__fill_1
XFILLER_16_163 VDD VDD VSS VSS gf180mcu_fd_sc_mcu7t5v0__fillcap_8
XTAP_TAPCELL_ROW_63_1104 VDD VSS gf180mcu_fd_sc_mcu7t5v0__filltie
XTAP_TAPCELL_ROW_123_1890 VDD VSS gf180mcu_fd_sc_mcu7t5v0__filltie
XFILLER_16_185 VDD VDD VSS VSS gf180mcu_fd_sc_mcu7t5v0__fillcap_4
XFILLER_20_807 VDD VDD VSS VSS gf180mcu_fd_sc_mcu7t5v0__fillcap_64
XFILLER_32_667 VDD VDD VSS VSS gf180mcu_fd_sc_mcu7t5v0__fillcap_64
X_2810_ place86/Z _3857_/Q _2816_/S _3857_/D VDD VDD VSS VSS gf180mcu_fd_sc_mcu7t5v0__mux2_2
X_3790_ _3790_/D _3806_/CLK _3790_/Q VDD VDD VSS VSS gf180mcu_fd_sc_mcu7t5v0__dffq_1
X_2672_ place85/Z _3794_/Q _2676_/S _3794_/D VDD VDD VSS VSS gf180mcu_fd_sc_mcu7t5v0__mux2_2
XFILLER_125_282 VDD VDD VSS VSS gf180mcu_fd_sc_mcu7t5v0__fillcap_64
XFILLER_113_422 VDD VDD VSS VSS gf180mcu_fd_sc_mcu7t5v0__fillcap_4
XTAP_TAPCELL_ROW_74_1244 VDD VSS gf180mcu_fd_sc_mcu7t5v0__filltie
XFILLER_101_628 VDD VDD VSS VSS gf180mcu_fd_sc_mcu7t5v0__fill_2
XFILLER_98_177 VDD VDD VSS VSS gf180mcu_fd_sc_mcu7t5v0__fillcap_64
XFILLER_86_317 VDD VDD VSS VSS gf180mcu_fd_sc_mcu7t5v0__fillcap_8
.ends
